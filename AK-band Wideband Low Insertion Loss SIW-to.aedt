# Ansys Electronics Desktop project, version 2021.2
materials:
  vacuum: permittivity=1
  Rogers RO4450F (tm): permittivity=3.52 dielectric_loss_tangent=0.004
  Rogers RO4350 (tm): permittivity=3.66 dielectric_loss_tangent=0.004
  copper: permeability=0.999991 conductivity=58000000
  air: permittivity=1.0006 permeability=1.0000004
  pec: conductivity=1e+30

design original (HFSS, DrivenModal, model units mm)
variables:
  PP_thickness = 0.23mm
  m_thickness = 0.168mm
  m_length = 40mm
  m_width = 20mm
  line_thickness = 0.035mm
  WG_width = 10.668mm
  WG_length = 4.318mm
  WG_high = 20mm
  WG_thickness = 1mm
  I2 = 0.7mm
  W2 = 3.6mm
  I3 = 0.57mm
  W3 = 0.36mm
  I4 = 0.58mm
  W4 = 0.36mm
  W5 = 2.36mm
  I5 = 1.47mm
  h3 = 2.8mm
  h4 = 5.13mm
  h1 = 1.64mm
  h2 = 1.24mm
  via_radius = 0.175mm
  w6 = 7.87mm
  w7 = 2.14mm
  w8 = 0.35mm
  w9 = 0.175mm
  GCPw_length = 3mm
geometry:
  PP [Rogers RO4450F (tm)] = box(corner=(-m_length /2, - m_width/2, - PP_thickness /2), size=(m_length, m_width, PP_thickness))
  m_1 [Rogers RO4350 (tm)] = box(corner=(-m_length /2, - m_width/2, PP_thickness /2 + line_thickness), size=(m_length, m_width, m_thickness))
  m_2 [Rogers RO4350 (tm)] = box(corner=(-m_length /2, - m_width/2, - PP_thickness /2 - m_thickness -line_thickness), size=(m_length, m_width, m_thickness))
  layer_1 [copper] = box(corner=(-m_length /2, - m_width/2, PP_thickness /2 + line_thickness +m_thickness), size=(m_length, m_width, line_thickness))
  layer_2 [copper] = box(corner=(-m_length /2, - m_width/2, PP_thickness /2), size=(m_length, m_width, line_thickness))
  layer_3 [copper] = box(corner=(-m_length /2, - m_width/2, - PP_thickness /2 - line_thickness), size=(m_length, m_width, line_thickness))
  layer_1_sub = box(corner=(-WG_length /2, - WG_width /2, PP_thickness /2 + line_thickness +m_thickness), size=(WG_length, WG_width, line_thickness))
  WG_sub = box(corner=(-WG_length /2, - WG_width /2, PP_thickness /2 + line_thickness *2+m_thickness), size=(WG_length, WG_width, WG_high))
  layer_1.subtract(layer_1_sub)
  WG [copper] = box(corner=(-(WG_length+ WG_thickness *2 )/2, - (WG_width+ WG_thickness *2)/2, PP_thickness /2 + line_thickness *2+m_thickness), size=(WG_length + WG_thickness *2, WG_width + WG_thickness *2, WG_high))
  WG.subtract(WG_sub)
  ridge_1 [copper] = box(corner=(-WG_length  /2, - W2 /2, PP_thickness /2 + line_thickness +m_thickness), size=(I2, W2, line_thickness + h1 +h2))
  ridge_1_2 [copper] = box(corner=(-WG_length  /2 + I2, - W3 /2, PP_thickness /2 + line_thickness +m_thickness), size=(I3, W3, line_thickness))
  ridge_2 [copper] = box(corner=(WG_length  /2 -I4, - W5 /2, PP_thickness /2 + line_thickness +m_thickness), size=(I4, W5, line_thickness+h3+h4))
  ridge_2_2 [copper] = box(corner=(WG_length  /2 -I4 -I5, - W4 /2, PP_thickness /2 + line_thickness +m_thickness), size=(I5, W4, line_thickness+h3))
  ridge_1_2_2 [copper] = box(corner=(-WG_length  /2 + I2, - W3 /2, PP_thickness /2 + line_thickness +m_thickness + h2), size=(I3, W3, h1))
  via = cylinder(axis=Z, base_centre=(WG_length /2 +via_radius *2, - w6 /2, PP_thickness /2 + line_thickness), radius=via_radius, height=m_thickness)
  Rectangle1 = rectangle(corner=(11.7mm, - w6 /2  + via_radius*3, PP_thickness /2 + line_thickness +m_thickness), y_size=w7, z_size=line_thickness)
  Rectangle2 = rectangle(corner=(17mm, -w7 - w8 /2, PP_thickness /2 + line_thickness +m_thickness), y_size=w7, z_size=line_thickness)
  MS_gap = box(corner=(m_length /2, - (w8+w9*2) /2, PP_thickness /2 + line_thickness +m_thickness), size=(- GCPw_length, w8 +w9*2, line_thickness))
  Rectangle1.connect(Rectangle2)
  Rectangle1_1 = Rectangle1.duplicate_mirror(point=(0mm, 0mm, 0mm), normal=(0mm, -1mm, 0mm))
  layer_1.subtract(Rectangle1, Rectangle1_1)
  MS [copper] = box(corner=(m_length /2, - (w8) /2, PP_thickness /2 + line_thickness +m_thickness), size=(- GCPw_length, w8, line_thickness))
  layer_1.subtract(MS_gap)
  Rectangle3 = rectangle(corner=(-(WG_length+ WG_thickness *2 )/2, - (WG_width+ WG_thickness *2)/2, PP_thickness /2 + line_thickness *2+m_thickness +WG_high), x_size=WG_length+ WG_thickness *2, y_size=WG_width+ WG_thickness *2)
  Box1 [pec] = box(corner=(-(WG_length+ WG_thickness *2 )/2, - (WG_width+ WG_thickness *2)/2, PP_thickness /2 + line_thickness *2+m_thickness +WG_high), size=(WG_length+ WG_thickness *2, WG_width+ WG_thickness *2, 0.1mm))
  Rectangle4 = rectangle(corner=(m_length /2, - ( w8+w9*2 )*4 /2, PP_thickness /2), y_size=(w8+w9*2)*4, z_size=m_thickness *8)
  Box2 [pec] = box(corner=(m_length /2, - ( w8+w9*2 )*4 /2, PP_thickness /2), size=(0.1mm, ( w8+w9*2 )*4, m_thickness*8))
  Region [air] = region(percentage_offset=30 on all sides)
  via_13..via_25 = via.duplicate_along_line(step=(0.7mm, 0mm, 0mm), total=14)
  via_25_1..via_25_8 = via_25.duplicate_along_line(step=(0.68mm, 0.15mm, 0mm), total=9)
  via_25_8_1 = via_25_8.duplicate_along_line(step=(0.251mm, 0.535mm, 0mm), total=2)
  via_25_8_1_1, via_25_8_1_2 = via_25_8_1.duplicate_along_line(step=(0mm, 0.7mm, 0mm), total=3)
  via_25_8_1_2_1..via_25_8_1_2_4 = via_25_8_1_2.duplicate_along_line(step=(0.57mm, 0mm, 0mm), total=5)
  via_27, via_28, via_29 = via.duplicate_along_line(step=(0mm, -0.7mm, 0mm), total=4)
  via_29_1 = via_29.duplicate_along_line(step=(-0.609mm, 0.235mm, 0mm), total=2)
  via_29_1_1..via_29_1_6 = via_29_1.duplicate_along_line(step=(-0.71mm, 0mm, 0mm), total=7)
  via_29_1_6_1..via_29_1_6_8 = via_29_1_6.duplicate_along_line(step=(0mm, 0.7mm, 0mm), total=9)
  via_30 = via.duplicate_mirror(point=(0mm, 0mm, 0mm), normal=(0mm, 1mm, 0mm))
  via.unite(via_13..via_25, via_25_1..via_25_8, via_25_8_1, via_25_8_1_1, via_25_8_1_2, via_25_8_1_2_1..via_25_8_1_2_4, via_27, via_28, via_29, via_29_1, via_29_1_1..via_29_1_6, via_29_1_6_1..via_29_1_6_8, via_30)
  via_31 [copper] = via.duplicate_mirror(point=(0mm, 0mm, 0mm), normal=(0mm, 1mm, 0mm))
  via_31.unite(via)
boundaries and excitations:
  Rad1: Radiation Objects=Region
  1: Wave Port Objects=Rectangle3 NumModes=1 Modes{Mode1{CharImp=Zpi}}
  2: Wave Port Objects=Rectangle4 NumModes=1 Modes{Mode1{CharImp=Zpi}}
setups:
  Setup1: HfssDriven Frequency=22.5GHz MaxDeltaS=0.02 MaximumPasses=11 MinimumPasses=1 MinimumConvergedPasses=1 PercentRefinement=30 BasisOrder=1 PortAccuracy=2
    sweep Sweep: 18GHz to 27GHz step 0.05GHz; Type=Interpolating InterpTolerance=0.5 InterpMaxSolns=250 InterpUsePortImped=false PassivityErrorTolerance=0.0001
source amplitudes:
  1:1: 1W 0deg
  2:1: 0W 0deg
optimetrics:
  ParametricSetup1: Parametric Sim._Setups=[Setup1]
    sweep I5: 1.77mm
  ParametricSetup2: Parametric Sim._Setups=[Setup1]
    sweep I5: LIN 1.47mm 2.07mm 0.1mm
    sweep I3: LIN 0.57mm 1.07mm 0.1mm
  ParametricSetup3: Parametric Sim._Setups=[Setup1]
    sweep W5: LIN 2.16mm 2.56mm 0.2mm
  ParametricSetup4: Parametric Sim._Setups=[Setup1]
    sweep m_thickness: LIN 0.168mm 0.368mm 0.1mm
  ParametricSetup5: Parametric Sim._Setups=[Setup1]
    sweep I5: LIN 0.47mm 1.97mm 0.5mm
  ParametricSetup6: Parametric Sim._Setups=[Setup1]
    sweep w6: 8.2mm
  ParametricSetup7: Parametric Sim._Setups=[Setup1]
    sweep w7: LIN 1.64mm 2.64mm 0.5mm
  ParametricSetup8: Parametric Sim._Setups=[Setup1]
    sweep w8: LIN 0.25mm 0.55mm 0.1mm
field plots:
  Mag_E1: E Field in m_1 on Setup1 : LastAdaptive at Freq=22.5GHz Phase=0deg
reports:
  S Parameter Plot 1: dB(S(1,1)), dB(S(2,1)) vs Freq on Setup1 : Sweep
  S Parameter Plot 2: dB(S(2,1)) vs Freq on Setup1 : Sweep [w6=all]
  S Parameter Plot 3: dB(S(2,1)) vs Freq on Setup1 : Sweep [w8=all]

design best (HFSS, DrivenModal, model units mm)
variables:
  PP_thickness = 0.23mm
  m_thickness = 0.368mm
  m_length = 40mm
  m_width = 20mm
  line_thickness = 0.035mm
  WG_width = 10.668mm
  WG_length = 4.318mm
  WG_high = 20mm
  WG_thickness = 1mm
  I2 = 0.7mm
  W2 = 3.6mm
  I3 = 0.57mm
  W3 = 0.36mm
  I4 = 0.58mm
  W4 = 0.36mm
  W5 = 4.318mm  # original 2.36
  I5 = 1.77mm
  h3 = 2.8mm
  h4 = 5.13mm
  h1 = 1.64mm
  h2 = 1.24mm
  via_radius = 0.175mm
  w6 = 7.87mm
  w7 = 2.14mm
  w8 = 0.35mm
  w9 = 0.175mm
  GCPw_length = 3mm
geometry:
  PP [Rogers RO4450F (tm)] = box(corner=(-m_length /2, - m_width/2, - PP_thickness /2), size=(m_length, m_width, PP_thickness))
  m_1 [Rogers RO4350 (tm)] = box(corner=(-m_length /2, - m_width/2, PP_thickness /2 + line_thickness), size=(m_length, m_width, m_thickness))
  m_2 [Rogers RO4350 (tm)] = box(corner=(-m_length /2, - m_width/2, - PP_thickness /2 - m_thickness -line_thickness), size=(m_length, m_width, m_thickness))
  layer_1 [copper] = box(corner=(-m_length /2, - m_width/2, PP_thickness /2 + line_thickness +m_thickness), size=(m_length, m_width, line_thickness))
  layer_2 [copper] = box(corner=(-m_length /2, - m_width/2, PP_thickness /2), size=(m_length, m_width, line_thickness))
  layer_3 [copper] = box(corner=(-m_length /2, - m_width/2, - PP_thickness /2 - line_thickness), size=(m_length, m_width, line_thickness))
  layer_4 [copper] = box(corner=(-m_length /2, - m_width/2, - PP_thickness /2 - line_thickness *2 - m_thickness), size=(m_length, m_width, line_thickness))
  layer_1_sub = box(corner=(-WG_length /2, - WG_width /2, PP_thickness /2 + line_thickness +m_thickness), size=(WG_length, WG_width, line_thickness))
  WG_sub = box(corner=(-WG_length /2, - WG_width /2, PP_thickness /2 + line_thickness *2+m_thickness), size=(WG_length, WG_width, WG_high))
  layer_1.subtract(layer_1_sub)
  WG [copper] = box(corner=(-(WG_length+ WG_thickness *2 )/2, - (WG_width+ WG_thickness *2)/2, PP_thickness /2 + line_thickness *2+m_thickness), size=(WG_length + WG_thickness *2, WG_width + WG_thickness *2, WG_high))
  WG.subtract(WG_sub)
  ridge_1 [copper] = box(corner=(-WG_length  /2, - W2 /2, PP_thickness /2 + line_thickness +m_thickness), size=(I2, W2, line_thickness + h1 +h2))
  ridge_1_2 [copper] = box(corner=(-WG_length  /2 + I2, - W3 /2, PP_thickness /2 + line_thickness +m_thickness), size=(I3, W3, line_thickness))
  ridge_2 [copper] = box(corner=(WG_length  /2 -I4, - W5 /2, PP_thickness /2 + line_thickness +m_thickness), size=(I4, W5, line_thickness+h3+h4))
  ridge_2_2 [copper] = box(corner=(WG_length  /2 -I4 -I5, - W4 /2, PP_thickness /2 + line_thickness +m_thickness), size=(I5, W4, line_thickness+h3))
  ridge_1_2_2 [copper] = box(corner=(-WG_length  /2 + I2, - W3 /2, PP_thickness /2 + line_thickness +m_thickness + h2), size=(I3, W3, h1))
  via [copper] = cylinder(axis=Z, base_centre=(WG_length /2 +via_radius *2, - w6 /2, PP_thickness /2 + line_thickness), radius=via_radius, height=m_thickness)
  Rectangle1 = rectangle(corner=(14mm, - w6 /2  + via_radius*4, PP_thickness /2 + line_thickness +m_thickness), y_size=w7, z_size=line_thickness)
  Rectangle2 = rectangle(corner=(17mm, -w7 - w8 /2, PP_thickness /2 + line_thickness +m_thickness), y_size=w7, z_size=line_thickness)
  MS_gap = box(corner=(m_length /2, - (w8+w9*2) /2, PP_thickness /2 + line_thickness +m_thickness), size=(- GCPw_length, w8 +w9*2, line_thickness))
  Rectangle1.connect(Rectangle2)
  Rectangle1_1 = Rectangle1.duplicate_mirror(point=(0mm, 0mm, 0mm), normal=(0mm, -1mm, 0mm))
  layer_1.subtract(Rectangle1, Rectangle1_1)
  MS [copper] = box(corner=(m_length /2, - (w8) /2, PP_thickness /2 + line_thickness +m_thickness), size=(- GCPw_length, w8, line_thickness))
  layer_1.subtract(MS_gap)
  Rectangle3 = rectangle(corner=(-(WG_length+ WG_thickness *2 )/2, - (WG_width+ WG_thickness *2)/2, PP_thickness /2 + line_thickness *2+m_thickness +WG_high), x_size=WG_length+ WG_thickness *2, y_size=WG_width+ WG_thickness *2)
  Box1 [pec] = box(corner=(-(WG_length+ WG_thickness *2 )/2, - (WG_width+ WG_thickness *2)/2, PP_thickness /2 + line_thickness *2+m_thickness +WG_high), size=(WG_length+ WG_thickness *2, WG_width+ WG_thickness *2, 0.1mm))
  Rectangle4 = rectangle(corner=(m_length /2, - ( w8+w9*2 )*4 /2, PP_thickness /2), y_size=(w8+w9*2)*4, z_size=m_thickness *5)
  Box2 [pec] = box(corner=(m_length /2, - ( w8+w9*2 )*4 /2, PP_thickness /2), size=(0.1mm, ( w8+w9*2 )*4, m_thickness*5))
  Region [air] = region(percentage_offset=30 on all sides)
  via_13..via_25 = via.duplicate_along_line(step=(0.7mm, 0mm, 0mm), total=14)
  via_25_1..via_25_8 = via_25.duplicate_along_line(step=(0.68mm, 0.15mm, 0mm), total=9)
  via_25_8_1 = via_25_8.duplicate_along_line(step=(0.251mm, 0.535mm, 0mm), total=2)
  via_25_8_1_1, via_25_8_1_2 = via_25_8_1.duplicate_along_line(step=(0mm, 0.7mm, 0mm), total=3)
  via_25_8_1_2_1..via_25_8_1_2_4 = via_25_8_1_2.duplicate_along_line(step=(0.57mm, 0mm, 0mm), total=5)
  via_27, via_28, via_29 = via.duplicate_along_line(step=(0mm, -0.7mm, 0mm), total=4)
  via_29_1 = via_29.duplicate_along_line(step=(-0.609mm, 0.235mm, 0mm), total=2)
  via_29_1_1..via_29_1_6 = via_29_1.duplicate_along_line(step=(-0.71mm, 0mm, 0mm), total=7)
  via_29_1_6_1..via_29_1_6_8 = via_29_1_6.duplicate_along_line(step=(0mm, 0.7mm, 0mm), total=9)
  via.unite(via_13..via_25, via_25_1..via_25_8, via_25_8_1, via_25_8_1_1, via_25_8_1_2, via_25_8_1_2_1..via_25_8_1_2_4, via_27, via_28, via_29, via_29_1, via_29_1_1..via_29_1_6, via_29_1_6_1..via_29_1_6_8)
  via_30 [copper] = via.duplicate_mirror(point=(0mm, 0mm, 0mm), normal=(0mm, 1mm, 0mm))
boundaries and excitations:
  Rad1: Radiation Objects=Region
  1: Wave Port Objects=Rectangle3 NumModes=1 Modes{Mode1{CharImp=Zpi}}
  2: Wave Port Objects=Rectangle4 NumModes=1 Modes{Mode1{CharImp=Zpi}}
setups:
  Setup1: HfssDriven Frequency=22.5GHz MaxDeltaS=0.02 MaximumPasses=11 MinimumPasses=1 MinimumConvergedPasses=1 PercentRefinement=30 BasisOrder=1 PortAccuracy=2
    sweep Sweep: 18GHz to 27GHz step 0.05GHz; Type=Interpolating InterpTolerance=0.5 InterpMaxSolns=250 InterpUsePortImped=false PassivityErrorTolerance=0.0001
source amplitudes:
  1:1: 1W 0deg
  2:1: 0W 0deg
optimetrics:
  ParametricSetup1: Parametric Sim._Setups=[Setup1]
    sweep I5: LIN 1.47mm 1.77mm 0.05mm
  ParametricSetup2: Parametric Sim._Setups=[Setup1]
    sweep I5: LIN 1.47mm 2.07mm 0.1mm
    sweep I3: LIN 0.57mm 1.07mm 0.1mm
  ParametricSetup3: Parametric Sim._Setups=[Setup1]
    sweep W5: LIN 3.16mm 4.16mm 0.2mm
    sweep I5: LIN 1.57mm 2.17mm 0.2mm
  ParametricSetup4: Parametric Sim._Setups=[Setup1]
    sweep m_thickness: LIN 0.168mm 0.368mm 0.1mm
  ParametricSetup5: Parametric Sim._Setups=[Setup1]
    sweep W5: 4.318mm
  ParametricSetup6: Parametric Sim._Setups=[Setup1]
    sweep I4: LIN 0.38mm 1.18mm 0.2mm
  ParametricSetup7: Parametric Sim._Setups=[Setup1]
    sweep W2: LIN 3.6mm 5.6mm 0.5mm
  ParametricSetup8: Parametric Sim._Setups=[Setup1]
    sweep w8: LIN 0.55mm 0.65mm 0.02mm
    sweep w9: LIN 0.1mm 0.25mm 0.025mm
  ParametricSetup9: Parametric Sim._Setups=[Setup1]
    sweep w8: 0.55mm
    sweep w9: 0.1mm
field plots:
  Mag_E1: E Field in m_1 on Setup1 : LastAdaptive at Freq=22.5GHz Phase=0deg
reports:
  S Parameter Plot 1: dB(S(1,1)), dB(S(2,1)) vs Freq on Setup1 : Sweep; markers MY1 at y=-1
