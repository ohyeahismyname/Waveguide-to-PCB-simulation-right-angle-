# Ansys Electronics Desktop project, version 2021.2
materials:
  air: permittivity=1.0006 permeability=1.0000004
  pec: conductivity=1e+30
  vacuum: permittivity=1
  Rogers RT/duroid 6010/6010LM (tm): permittivity=10.2 dielectric_loss_tangent=0.0023
  copper: permeability=0.999991 conductivity=58000000

design btb (HFSS, DrivenModal, model units mm)
geometry:
  fixture_down1 = component(fixture_down, 3D_Component_File_Path="C:/Users/ccsp/Desktop/CHE ZHENG/ASE_2025/transition_strucutre(WG-CPW)/WR90_model/fixture_down.a3dcomp", m_thickness=0.635mm, m_width=8.2mm, m_length=25mm, WG_length=10.16mm, WG_width=22.86mm, via_radius=0.225mm, WG_short_high=4.408mm, WG_thickness=1.5mm, line_thickness=0.035mm, housing_high=7.9mm, fixture_width=30mm, fixture_high=10mm)
  down_fixture [copper] = part_of(fixture_down1)
  6010_via_back_best1 = component(6010_via_back_best, 3D_Component_File_Path="C:/Users/ccsp/Desktop/CHE ZHENG/ASE_2025/transition_strucutre(WG-CPW)/WR90_model/WR90PCB.a3dcomp", m_thickness=0.635mm, m_width=8.2mm, m_length=25mm, WG_length=10.16mm, via_radius=0.225mm, line_thickness=0.035mm, MS_width=1.5mm, gap=0.41mm, patch_length=2.5mm, patch_width=4mm, MS_add_dis=0.95mm, patch_sub_ratio=0.7)
  medium [Rogers RT/duroid 6010/6010LM (tm)] = part_of(6010_via_back_best1)
  layer1, MS, patch, via, via_17, via_back, layer2 [copper] = part_of(6010_via_back_best1)
  6010_via_back_best1.rotate(RotateAxis=X RotateAngle=180deg)
  6010_via_back_best1.move(TranslateVectorX=12.5mm TranslateVectorY=0mm TranslateVectorZ=9.6475mm)
  6010_via_back_best1.duplicate_mirror(DuplicateMirrorBaseX=0mm DuplicateMirrorBaseY=0mm DuplicateMirrorBaseZ=0mm DuplicateMirrorNormalX=1mm DuplicateMirrorNormalY=0mm DuplicateMirrorNormalZ=0mm)
  6010_via_back_best2 = component(6010_via_back_best)
  6010_via_back_best2.from_dup_mirror(SourceID=1477 WhichClone=0)
  fixture_upper1 = component(fixture_upper, 3D_Component_File_Path="C:/Users/ccsp/Desktop/CHE ZHENG/ASE_2025/transition_strucutre(WG-CPW)/WR90_model/fixture_upper.a3dcomp", m_width=8.2mm, m_length=25mm, WG_length=10.16mm, WG_width=22.86mm, via_radius=0.225mm, housing_high=7.9mm, fixture_length=54.35mm, fixture_width=30mm, fixture_high=15mm)
  upper_fixture [copper] = part_of(fixture_upper1)
  fixture_upper1.move(TranslateVectorX=0mm TranslateVectorY=0mm TranslateVectorZ=10mm)
  Region [air] = region(percentage_offset=50 on all sides)
  waveport1 = rectangle(corner=(14.165mm, -11.43mm, 25mm), x_size=10.16mm, y_size=22.86mm)
  waveport_1 [pec] = box(corner=(14.165mm, -11.43mm, 25mm), size=(10.16mm, 22.86mm, 0.1mm))
  waveport_1_1 [pec] = waveport_1.duplicate_mirror(point=(0mm, 0mm, 0mm), normal=(1mm, 0mm, 0mm))
  waveport1_1 = waveport1.duplicate_mirror(point=(0mm, 0mm, 0mm), normal=(1mm, 0mm, 0mm))
boundaries and excitations:
  Rad1: Radiation Objects=Region
  1: Wave Port Objects=waveport1 NumModes=1 Modes{Mode1{CharImp=Zpi}}
  2: Wave Port Objects=waveport1_1 NumModes=1 Modes{Mode1{CharImp=Zpi}}
setups:
  Setup1: HfssDriven Frequency=10.5GHz MaxDeltaS=0.02 MaximumPasses=15 MinimumPasses=2 MinimumConvergedPasses=2 PercentRefinement=30 BasisOrder=1 PortAccuracy=2
    sweep Sweep: 8GHz to 13GHz step 0.05GHz; Type=Interpolating InterpTolerance=0.5 InterpMaxSolns=250 InterpUsePortImped=false PassivityErrorTolerance=0.0001
source amplitudes:
  1:1: 1W 0deg
  2:1: 0W 0deg
reports:
  S Parameter Plot 1: dB(S(1,1)), dB(S(2,1)) vs Freq on Setup1 : Sweep

design original (HFSS, DrivenModal, model units mm)
variables:
  m_thickness = 0.635mm
  m_width = 8.2mm
  m_length = 25mm
  WG_length = 10.16mm
  WG_width = 22.86mm
  WG_high = 14.408mm
  via_radius = 0.225mm
  WG_short_high = 4.408mm
  WG_thickness = 1.5mm
  line_thickness = 0.035mm
  MS_width = 1.5mm
  gap = 0.41mm
  patch_length = 2.5mm
  patch_width = 4mm
  MS_add_dis = 0.95mm
  housing_high = 7.9mm
  housing_thickness = WG_thickness
  patch_sub_radius = 1.75mm
  patch_ratio = 0.7mm
  patch_sub_ratio = 0.7
geometry:
  medium [Rogers RT/duroid 6010/6010LM (tm)] = box(corner=(- m_length /2, - m_width /2, -m_thickness /2), size=(m_length, m_width, m_thickness))
  WG_sub = box(corner=(m_length /2 - via_radius *3, - WG_width /2, m_thickness /2 + WG_short_high), size=(- WG_length, WG_width, - WG_high))
  WG [copper] = box(corner=(( m_length+ WG_thickness *2 ) /2 - via_radius *3, - ( WG_width + WG_thickness *2- via_radius *3)/2, m_thickness /2 + WG_short_high +WG_thickness), size=(- ( WG_length + WG_thickness *2), WG_width + WG_thickness *2, - ( WG_high + WG_thickness )))
  layer1 [copper] = box(corner=(- m_length /2, - m_width /2, - m_thickness /2 - line_thickness), size=(m_length  - WG_length - via_radius *3, m_width, line_thickness))
  WG_sub_1 = WG_sub.copy()
  WG_sub.delete()
  WG.subtract(WG_sub_1)
  layer1_sub = box(corner=(- m_length /2, -  ( MS_width + gap *2  ) /2, - m_thickness /2 - line_thickness), size=(m_length  - WG_length - via_radius *3, MS_width + gap *2, line_thickness))
  MS [copper] = box(corner=(- m_length /2, -  ( MS_width   ) /2, - m_thickness /2 - line_thickness), size=(m_length  - WG_length - via_radius *3 +MS_add_dis, MS_width, line_thickness))
  patch [copper] = box(corner=(m_length /2 - via_radius *3  - WG_length + MS_add_dis, - patch_width /2, - m_thickness /2 - line_thickness), size=(patch_length, patch_width, line_thickness))
  housing_sub = box(corner=(- m_length /2, - m_width /2, -housing_high /2), size=(m_length  - WG_length, m_width, housing_high))
  housing = box(corner=(- m_length /2, - (m_width+ housing_thickness *2) /2, - ( housing_high+ housing_thickness *2 )  /2), size=(m_length  - WG_length -via_radius *3, m_width + housing_thickness *2, housing_high + housing_thickness *2))
  housing_sub_1 = housing_sub.copy()
  housing.subtract(housing_sub_1)
  layer1.subtract(layer1_sub)
  waveport1 = rectangle(corner=(- m_length /2, -3* ( 2*gap + MS_width ) /2, - ( 5* m_thickness )  /2), y_size=3* ( 2*gap + MS_width ), z_size=5* m_thickness)
  waveport_1 [pec] = box(corner=(- m_length /2, -3* ( 2*gap + MS_width ) /2, - ( 5* m_thickness )  /2), size=(-0.1mm, 3* ( 2*gap + MS_width ), 5* m_thickness))
  waveport_2 [pec] = box(corner=(( m_length+ WG_thickness *2 ) /2 - via_radius *3, - ( WG_width + WG_thickness *2- via_radius *3)/2, m_thickness /2 + WG_short_high - WG_high), size=(- ( WG_length + WG_thickness *2), WG_width + WG_thickness *2, -0.1mm))
  waveport2 = rectangle(corner=(( m_length+ WG_thickness *2 ) /2 - via_radius *3, - ( WG_width + WG_thickness *2- via_radius *3)/2, m_thickness /2 + WG_short_high - WG_high), x_size=- ( WG_length + WG_thickness *2), y_size=WG_width + WG_thickness *2)
  via [copper] = cylinder(axis=Z, base_centre=(- m_length /2 + via_radius *2, m_width /2 -via_radius *2, - m_thickness /2), radius=via_radius, height=m_thickness)
  via_1..via_16 = via.duplicate_along_line(step=(0.8mm, 0mm, 0mm), total=17)
  via.unite(via_1..via_16)
  via_17 [copper] = via.duplicate_mirror(point=(0mm, 0mm, 0mm), normal=(0mm, 1mm, 0mm))
  via_18 = via.copy()
  via_17_1 = via_17.copy()
  medium.subtract(via_18, via_17_1)
  housing_1 = housing.copy()
  housing_sub_2 = housing_sub.copy()
  housing_sub.delete()
  WG.subtract(housing_1, housing_sub_2)
  Region [air] = region(percentage_offset=30 on all sides)
  Ellipse1 = ellipse(normal=Z, centre=(0mm, 0mm, - m_thickness /2 - line_thickness), major_radius=1.75mm, ratio=patch_sub_ratio)
  Ellipse1.rotate(axis=Z, angle=90deg)
  Ellipse1.move(m_length /2 - via_radius *3  - WG_length + MS_add_dis + patch_length, 0mm, 0mm)
  Ellipse1.thicken(0.035mm)
  Ellipse1_1 = Ellipse1.copy()
  Ellipse1.delete()
  patch.subtract(Ellipse1_1)
  medium_1 = medium.copy()
  WG.subtract(medium_1)
  via_back [copper] = cylinder(axis=Z, base_centre=(m_length /2 - via_radius*1.5, m_width /2 - via_radius *2, - m_thickness /2), radius=via_radius, height=m_thickness)
  via_back_1..via_back_9 = via_back.duplicate_along_line(step=(0mm, -0.8mm, 0mm), total=10)
  via_back.unite(via_back_1..via_back_9)
  via_back_10 = via_back.copy()
  medium.subtract(via_back_10)
  layer2 [copper] = box(corner=(m_length /2, - m_width /2, - m_thickness /2 - line_thickness), size=(- via_radius *3, m_width, line_thickness))
  WG.unite(housing)
boundaries and excitations:
  Rad1: Radiation Objects=Region
  1: Wave Port Objects=waveport1 NumModes=1 Modes{Mode1{CharImp=Zpi}}
  2: Wave Port Objects=waveport2 NumModes=1 Modes{Mode1{CharImp=Zpi}}
setups:
  Setup1: HfssDriven Frequency=10.5GHz MaxDeltaS=0.02 MaximumPasses=6 MinimumPasses=1 MinimumConvergedPasses=1 PercentRefinement=30 BasisOrder=1 PortAccuracy=2
    sweep Sweep: 8GHz to 13GHz step 0.05GHz; Type=Interpolating InterpTolerance=0.5 InterpMaxSolns=250 InterpUsePortImped=false PassivityErrorTolerance=0.0001
source amplitudes:
  1:1: 1W 0deg
  2:1: 0W 0deg
optimetrics:
  ParametricSetup1: Parametric Sim._Setups=[Setup1]
    sweep patch_sub_ratio: LIN 0.7 1 0.1
  ParametricSetup2: Parametric Sim._Setups=[Setup1]
    sweep patch_sub_ratio: LIN 0.7 0.9 0.05
field plots:
  Mag_E1: E Field in Region on Setup1 : LastAdaptive at Freq=10.5GHz Phase=0deg
  Mag_E2: E Field in medium on Setup1 : LastAdaptive at Freq=10.5GHz Phase=0deg
reports:
  S Parameter Plot 1: dB(S(1,1)), dB(S(2,1)) vs Freq on Setup1 : Sweep; markers MX1 at x=1.05e+10, MY1 at y=-15, MY2 at y=-0.5
  S Parameter Plot 2: dB(S(1,1)) vs Freq on Setup1 : Sweep [patch_sub_ratio=all]; markers MX1 at x=1.05e+10
  S Parameter Plot 3: dB(S(1,1)) vs Freq on Setup1 : Sweep [patch_sub_ratio=all]

design 6010_WR34 (HFSS, DrivenModal, model units mm)
variables:
  m_thickness = 0.254mm
  m_width = 3.8mm
  m_length = 15mm
  WG_length = 4.318mm
  WG_width = 8.636mm
  WG_high = 11.57mm
  via_radius = 0.15mm
  WG_short_high = 1.57mm
  WG_thickness = 1.5mm
  line_thickness = 0.035mm
  MS_width = 0.56mm
  gap = 0.2mm
  patch_length = 0.85mm
  patch_width = 1.9mm
  MS_add_dis = 0.4mm
  housing_high = 2.6mm
  housing_thickness = WG_thickness
  patch_sub_radius = 0.6mm
  patch_ratio = 0.7mm
  patch_sub_ratio = 0.95
geometry:
  medium [Rogers RT/duroid 6010/6010LM (tm)] = box(corner=(- m_length /2, - m_width /2, -m_thickness /2), size=(m_length, m_width, m_thickness))
  WG_sub = box(corner=(m_length /2 - via_radius *3, - WG_width /2, m_thickness /2 + WG_short_high), size=(- WG_length, WG_width, - WG_high))
  WG [copper] = box(corner=(( m_length+ WG_thickness *2 ) /2 - via_radius *3, - ( WG_width + WG_thickness *2- via_radius *3)/2, m_thickness /2 + WG_short_high +WG_thickness), size=(- ( WG_length + WG_thickness *2), WG_width + WG_thickness *2, - ( WG_high + WG_thickness )))
  layer1 [copper] = box(corner=(- m_length /2, - m_width /2, - m_thickness /2 - line_thickness), size=(m_length  - WG_length - via_radius *3, m_width, line_thickness))
  WG_sub_1 = WG_sub.copy()
  WG_sub.delete()
  WG.subtract(WG_sub_1)
  layer1_sub = box(corner=(- m_length /2, -  ( MS_width + gap *2  ) /2, - m_thickness /2 - line_thickness), size=(m_length  - WG_length - via_radius *3, MS_width + gap *2, line_thickness))
  MS [copper] = box(corner=(- m_length /2, -  ( MS_width   ) /2, - m_thickness /2 - line_thickness), size=(m_length  - WG_length - via_radius *3 +MS_add_dis, MS_width, line_thickness))
  patch [copper] = box(corner=(m_length /2 - via_radius *3  - WG_length + MS_add_dis, - patch_width /2, - m_thickness /2 - line_thickness), size=(patch_length, patch_width, line_thickness))
  housing_sub = box(corner=(- m_length /2, - m_width /2, -housing_high /2), size=(m_length  - WG_length, m_width, housing_high))
  housing [copper] = box(corner=(- m_length /2, - (m_width+ housing_thickness *2) /2, - ( housing_high+ housing_thickness *2 )  /2), size=(m_length  - WG_length -via_radius *3, m_width + housing_thickness *2, housing_high + housing_thickness *2))
  housing_sub_1 = housing_sub.copy()
  housing.subtract(housing_sub_1)
  layer1.subtract(layer1_sub)
  waveport1 = rectangle(corner=(- m_length /2, -3* ( 2*gap + MS_width ) /2, - ( 5* m_thickness )  /2), y_size=3* ( 2*gap + MS_width ), z_size=5* m_thickness)
  waveport_1 [pec] = box(corner=(- m_length /2, -3* ( 2*gap + MS_width ) /2, - ( 5* m_thickness )  /2), size=(-0.1mm, 3* ( 2*gap + MS_width ), 5* m_thickness))
  waveport_2 [pec] = box(corner=(( m_length+ WG_thickness *2 ) /2 - via_radius *3, - ( WG_width + WG_thickness *2- via_radius *3)/2, m_thickness /2 + WG_short_high - WG_high), size=(- ( WG_length + WG_thickness *2), WG_width + WG_thickness *2, -0.1mm))
  waveport2 = rectangle(corner=(( m_length+ WG_thickness *2 ) /2 - via_radius *3, - ( WG_width + WG_thickness *2- via_radius *3)/2, m_thickness /2 + WG_short_high - WG_high), x_size=- ( WG_length + WG_thickness *2), y_size=WG_width + WG_thickness *2)
  via [copper] = cylinder(axis=Z, base_centre=(- m_length /2 + via_radius *2, m_width /2 -via_radius *2, - m_thickness /2), radius=via_radius, height=m_thickness)
  via_1..via_16 = via.duplicate_along_line(step=(0.6mm, 0mm, 0mm), total=17)
  via.unite(via_1..via_16)
  via_17 [copper] = via.duplicate_mirror(point=(0mm, 0mm, 0mm), normal=(0mm, 1mm, 0mm))
  via_18 = via.copy()
  via_17_1 = via_17.copy()
  medium.subtract(via_18, via_17_1)
  housing_1 = housing.copy()
  housing_sub_2 = housing_sub.copy()
  housing_sub.delete()
  WG.subtract(housing_1, housing_sub_2)
  Region [air] = region(percentage_offset=30 on all sides)
  Ellipse1 = ellipse(normal=Z, centre=(0mm, 0mm, - m_thickness /2 - line_thickness), major_radius=patch_sub_radius, ratio=patch_sub_ratio)
  Ellipse1.rotate(axis=Z, angle=90deg)
  Ellipse1.move(m_length /2 - via_radius *3  - WG_length + MS_add_dis + patch_length, 0mm, 0mm)
  Ellipse1.thicken(0.035mm)
  Ellipse1_1 = Ellipse1.copy()
  Ellipse1.delete()
  patch.subtract(Ellipse1_1)
  medium_1 = medium.copy()
  WG.subtract(medium_1)
  via_back [copper] = cylinder(axis=Z, base_centre=(m_length /2 - via_radius*1.5, m_width /2 - via_radius *2, - m_thickness /2), radius=via_radius, height=m_thickness)
  via_back_1..via_back_5 = via_back.duplicate_along_line(step=(0mm, -0.6mm, 0mm), total=6)
  via_back.unite(via_back_1..via_back_5)
  via_back_6 = via_back.copy()
  medium.subtract(via_back_6)
  layer2 [copper] = box(corner=(m_length /2, - m_width /2, - m_thickness /2 - line_thickness), size=(- via_radius *3, m_width, line_thickness))
boundaries and excitations:
  Rad1: Radiation Objects=Region
  1: Wave Port Objects=waveport1 NumModes=1 Modes{Mode1{CharImp=Zpi}}
  2: Wave Port Objects=waveport2 NumModes=1 Modes{Mode1{CharImp=Zpi}}
setups:
  Setup1: HfssDriven Frequency=28GHz MaxDeltaS=0.02 MaximumPasses=6 MinimumPasses=2 MinimumConvergedPasses=2 PercentRefinement=30 BasisOrder=1 PortAccuracy=2
    sweep Sweep: 22GHz to 33GHz step 0.05GHz; Type=Interpolating InterpTolerance=0.5 InterpMaxSolns=250 InterpUsePortImped=false PassivityErrorTolerance=0.0001
source amplitudes:
  1:1: 1W 0deg
  2:1: 0W 0deg
optimetrics:
  ParametricSetup1: Parametric Sim._Setups=[Setup1]
    sweep patch_sub_ratio: LIN 0.7 1 0.1
  ParametricSetup2: Parametric Sim._Setups=[Setup1]
    sweep patch_length: LIN 0.7mm 1.2mm 0.1mm
    sweep patch_width: LIN 1.2mm 1.5mm 0.1mm
    sweep MS_add_dis: LIN 0.25mm 0.65mm 0.1mm
    sweep patch_ratio: LIN 0.6mm 1mm 0.1mm
  ParametricSetup3: Parametric Sim._Setups=[Setup1]
    sweep patch_sub_ratio: LIN 0.7 1 0.1
    sweep MS_add_dis: LIN 0.25mm 0.55mm 0.1mm
    sweep patch_length: LIN 0.5mm 0.8mm 0.1mm
    sweep patch_width: LIN 1.3mm 1.9mm 0.2mm
  ParametricSetup4: Parametric Sim._Setups=[Setup1]
    sweep MS_add_dis: LIN 0.4mm 0.55mm 0.05mm
    sweep patch_length: LIN 0.6mm 0.85mm 0.05mm
    sweep patch_sub_ratio: LIN 0.9 1 0.05
    sweep patch_width: LIN 1.4mm 1.8mm 0.05mm
  ParametricSetup5: Parametric Sim._Setups=[Setup1]
    sweep patch_width: LIN 1.5mm 2mm 0.1mm
    sweep patch_sub_radius: LIN 0.4mm 0.8mm 0.1mm
  ParametricSetup6: Parametric Sim._Setups=[Setup1]
    sweep MS_add_dis: LIN 0.2mm 0.5mm 0.1mm
    sweep patch_length: LIN 0.65mm 0.95mm 0.1mm
    sweep patch_width: LIN 1.3mm 1.8mm 0.1mm
field plots:
  Mag_E1: E Field over MS.face(all 6) on Setup1 : LastAdaptive at Freq=28GHz Phase=0deg
reports:
  S Parameter Plot 1: dB(S(1,1)), dB(S(2,1)) vs Freq on Setup1 : Sweep; markers MX1 at x=2.8e+10, MY1 at y=-15, MY2 at y=-1

design original_larger_waveport (HFSS, DrivenModal, model units mm)
variables:
  m_thickness = 0.635mm
  m_width = 8.2mm
  m_length = 25mm
  WG_length = 10.16mm
  WG_width = 22.86mm
  WG_high = 14.408mm
  via_radius = 0.225mm
  WG_short_high = 4.408mm
  WG_thickness = 1.5mm
  line_thickness = 0.035mm
  MS_width = 1.5mm
  gap = 0.41mm
  patch_length = 2.5mm
  patch_width = 4mm
  MS_add_dis = 0.95mm
  housing_high = 7.9mm
  housing_thickness = WG_thickness
  patch_sub_radius = 1.75mm
  patch_ratio = 0.7mm
  patch_sub_ratio = 0.7
geometry:
  medium [Rogers RT/duroid 6010/6010LM (tm)] = box(corner=(- m_length /2, - m_width /2, -m_thickness /2), size=(m_length, m_width, m_thickness))
  WG_sub = box(corner=(m_length /2 - via_radius *3, - WG_width /2, m_thickness /2 + WG_short_high), size=(- WG_length, WG_width, - WG_high))
  WG [copper] = box(corner=(( m_length+ WG_thickness *2 ) /2 - via_radius *3, - ( WG_width + WG_thickness *2- via_radius *3)/2, m_thickness /2 + WG_short_high +WG_thickness), size=(- ( WG_length + WG_thickness *2), WG_width + WG_thickness *2, - ( WG_high + WG_thickness )))
  layer1 [copper] = box(corner=(- m_length /2, - m_width /2, - m_thickness /2 - line_thickness), size=(m_length  - WG_length - via_radius *3, m_width, line_thickness))
  WG_sub_1 = WG_sub.copy()
  WG_sub.delete()
  WG.subtract(WG_sub_1)
  layer1_sub = box(corner=(- m_length /2, -  ( MS_width + gap *2  ) /2, - m_thickness /2 - line_thickness), size=(m_length  - WG_length - via_radius *3, MS_width + gap *2, line_thickness))
  MS [copper] = box(corner=(- m_length /2, -  ( MS_width   ) /2, - m_thickness /2 - line_thickness), size=(m_length  - WG_length - via_radius *3 +MS_add_dis, MS_width, line_thickness))
  patch [copper] = box(corner=(m_length /2 - via_radius *3  - WG_length + MS_add_dis, - patch_width /2, - m_thickness /2 - line_thickness), size=(patch_length, patch_width, line_thickness))
  housing_sub = box(corner=(- m_length /2, - m_width /2, -housing_high /2), size=(m_length  - WG_length, m_width, housing_high))
  housing = box(corner=(- m_length /2, - (m_width+ housing_thickness *2) /2, - ( housing_high+ housing_thickness *2 )  /2), size=(m_length  - WG_length -via_radius *3, m_width + housing_thickness *2, housing_high + housing_thickness *2))
  housing_sub_1 = housing_sub.copy()
  housing.subtract(housing_sub_1)
  layer1.subtract(layer1_sub)
  waveport1 = rectangle(corner=(- m_length /2, -4* ( 2*gap + MS_width ) /2, - ( 14* m_thickness )  /2), y_size=4* ( 2*gap + MS_width ), z_size=14 * m_thickness)
  waveport_1 [pec] = box(corner=(- m_length /2, -4* ( 2*gap + MS_width ) /2, - ( 14* m_thickness )  /2), size=(-0.1mm, 4* ( 2*gap + MS_width ), 14* m_thickness))
  waveport_2 [pec] = box(corner=(( m_length+ WG_thickness *2 ) /2 - via_radius *3, - ( WG_width + WG_thickness *2- via_radius *3)/2, m_thickness /2 + WG_short_high - WG_high), size=(- ( WG_length + WG_thickness *2), WG_width + WG_thickness *2, -0.1mm))
  waveport2 = rectangle(corner=(( m_length+ WG_thickness *2 ) /2 - via_radius *3, - ( WG_width + WG_thickness *2- via_radius *3)/2, m_thickness /2 + WG_short_high - WG_high), x_size=- ( WG_length + WG_thickness *2), y_size=WG_width + WG_thickness *2)
  via [copper] = cylinder(axis=Z, base_centre=(- m_length /2 + via_radius *2, m_width /2 -via_radius *2, - m_thickness /2), radius=via_radius, height=m_thickness)
  via_1..via_16 = via.duplicate_along_line(step=(0.8mm, 0mm, 0mm), total=17)
  via.unite(via_1..via_16)
  via_17 [copper] = via.duplicate_mirror(point=(0mm, 0mm, 0mm), normal=(0mm, 1mm, 0mm))
  via_18 = via.copy()
  via_17_1 = via_17.copy()
  medium.subtract(via_18, via_17_1)
  housing_1 = housing.copy()
  housing_sub_2 = housing_sub.copy()
  housing_sub.delete()
  WG.subtract(housing_1, housing_sub_2)
  Region [air] = region(percentage_offset=30 on all sides)
  Ellipse1 = ellipse(normal=Z, centre=(0mm, 0mm, - m_thickness /2 - line_thickness), major_radius=1.75mm, ratio=patch_sub_ratio)
  Ellipse1.rotate(axis=Z, angle=90deg)
  Ellipse1.move(m_length /2 - via_radius *3  - WG_length + MS_add_dis + patch_length, 0mm, 0mm)
  Ellipse1.thicken(0.035mm)
  Ellipse1_1 = Ellipse1.copy()
  Ellipse1.delete()
  patch.subtract(Ellipse1_1)
  medium_1 = medium.copy()
  WG.subtract(medium_1)
  via_back [copper] = cylinder(axis=Z, base_centre=(m_length /2 - via_radius*1.5, m_width /2 - via_radius *2, - m_thickness /2), radius=via_radius, height=m_thickness)
  via_back_1..via_back_9 = via_back.duplicate_along_line(step=(0mm, -0.8mm, 0mm), total=10)
  via_back.unite(via_back_1..via_back_9)
  via_back_10 = via_back.copy()
  medium.subtract(via_back_10)
  layer2 [copper] = box(corner=(m_length /2, - m_width /2, - m_thickness /2 - line_thickness), size=(- via_radius *3, m_width, line_thickness))
  WG.unite(housing)
boundaries and excitations:
  Rad1: Radiation Objects=Region
  1: Wave Port Objects=waveport1 NumModes=1 Modes{Mode1{CharImp=Zpi}}
  2: Wave Port Objects=waveport2 NumModes=1 Modes{Mode1{CharImp=Zpi}}
setups:
  Setup1: HfssDriven Frequency=10.5GHz MaxDeltaS=0.02 MaximumPasses=6 MinimumPasses=1 MinimumConvergedPasses=1 PercentRefinement=30 BasisOrder=1 PortAccuracy=2
    sweep Sweep: 8GHz to 13GHz step 0.05GHz; Type=Interpolating InterpTolerance=0.5 InterpMaxSolns=250 InterpUsePortImped=false PassivityErrorTolerance=0.0001
source amplitudes:
  1:1: 1W 0deg
  2:1: 0W 0deg
field plots:
  Mag_E1: E Field in Region on Setup1 : LastAdaptive at Freq=10.5GHz Phase=0deg
  Mag_E2: E Field in medium on Setup1 : LastAdaptive at Freq=10.5GHz Phase=0deg
reports:
  S Parameter Plot 1: dB(S(1,1)), dB(S(2,1)) vs Freq on Setup1 : Sweep; markers MX1 at x=1.05e+10, MY1 at y=-15, MY2 at y=-0.5
  S Parameter Plot 2: dB(S(1,1)) vs Freq on Setup1 : Sweep [patch_sub_ratio=all]; markers MX1 at x=1.05e+10
  S Parameter Plot 3: dB(S(1,1)) vs Freq on Setup1 : Sweep [patch_sub_ratio=all]
