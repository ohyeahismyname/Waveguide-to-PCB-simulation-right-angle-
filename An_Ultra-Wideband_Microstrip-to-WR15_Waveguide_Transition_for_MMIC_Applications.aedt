# Ansys Electronics Desktop project, version 2021.2
materials:
  Rogers RO3003 (tm): permittivity=3 dielectric_loss_tangent=0.0013
  copper: permeability=0.999991 conductivity=58000000
  pec: conductivity=1e+30
  vacuum: permittivity=1
  Rogers RO4350 (tm): permittivity=3.66 dielectric_loss_tangent=0.004

design original (HFSS, DrivenModal, model units mm)
variables:
  m_length = 6mm
  m_width = 5mm
  m_thickness = 0.254mm
  line_thickness = 18um
  line_length = 1mm
  line_width = 1.22mm
  patch_length = 2.5mm
  patch_width = 3.76mm
  lT = 2mm
  connet_width = 2mm
  connet_width2 = line_width mm
  siw_width = 2.994mm
  via_radius = 0.15mm
  h_CA = 0.15mm
  WG_width = 3.76mm
  trans_0_high = 1.415mm
  trans_0_width = 0.285mm
  trans_1_width = 0.775mm
  trans_1_high = 1.448mm
  trans_2_width = 1.552mm
  trans_2_high = 1.478mm
  WG_high = 3mm
  WG_length = (3.76/2) mm
  SL_width = 0.556mm
  SL_length = 1mm
geometry:
  medium [Rogers RO4350 (tm)] = box(corner=(0mm, 0mm, 0mm), size=(m_length, m_width, m_thickness))
  ground [copper] = box(corner=(0mm, 0mm, -line_thickness), size=(m_length, m_width, line_thickness))
  SL [copper] = box(corner=(m_length - line_length, m_width/2 - SL_width/2, m_thickness), size=(SL_length, SL_width, line_thickness))
  probe [copper] = box(corner=(m_length - lT - patch_length, m_width/2 - patch_width /2+line_thickness, m_thickness), size=(patch_length, patch_width, line_thickness))
  Via [copper] = cylinder(axis=Z, base_centre=(m_length - lT - 0.2mm, (m_width - siw_width)/2 - via_radius, 0mm), radius=via_radius, height=m_thickness)
  Cylinder1_1..Cylinder1_4 = Via.duplicate_along_line(step=(-0.4mm, 0mm, 0mm), total=5)
  Via.unite(Cylinder1_4, Cylinder1_3, Cylinder1_2, Cylinder1_1)
  Via_1 [copper] = Via.duplicate_mirror(point=(3mm, 2.5mm, 0.25mm), normal=(0mm, -1mm, 0mm))
  WG_hole [vacuum] = box(corner=(m_length - lT - 5*0.4mm - via_radius, (m_width - WG_width) / 2  + line_thickness, -line_thickness), size=(h_CA, WG_width, line_thickness))
  via_back [copper, solve inside] = cylinder(axis=Z, base_centre=(m_length - lT - 5*0.4mm - via_radius*2.2, (m_width - WG_width) / 2 + via_radius * 2, 0), radius=via_radius, height=m_thickness)
  via_back_1..via_back_8 = via_back.duplicate_along_line(step=(0mm, 0.4mm, 0mm), total=9)
  via_back.unite(via_back_1..via_back_8)
  trans_0 [copper] = box(corner=(m_length - lT - 5*0.4mm - via_radius -0.0845mm, (m_width - WG_width) / 2, -trans_0_high - line_thickness), size=(trans_0_width+2 * line_thickness, WG_width+2*line_thickness, trans_0_high))
  trans_1 [copper] = box(corner=(m_length - lT - 5*0.4mm - via_radius -0.3295mm, (m_width - WG_width) / 2, -trans_0_high - line_thickness*2 -trans_1_high), size=(trans_1_width+2 * line_thickness, WG_width+2*line_thickness, trans_1_high +line_thickness))
  trans_0_sub [vacuum] = box(corner=(m_length - lT - 5*0.4mm - via_radius -0.0845mm +line_thickness, (m_width - WG_width) / 2  +line_thickness, -trans_0_high - line_thickness*2), size=(trans_0_width, WG_width, trans_0_high + line_thickness))
  trans_2 [copper] = box(corner=(m_length - lT - 5*0.4mm - via_radius -0.7180mm, (m_width - WG_width) / 2, -trans_0_high - line_thickness *3  -trans_1_high-trans_2_high), size=(trans_2_width+2 * line_thickness, WG_width+2*line_thickness, trans_2_high +line_thickness))
  trans_1_sub [vacuum] = box(corner=(m_length - lT - 5*0.4mm - via_radius -0.3295mm +line_thickness, (m_width - WG_width) / 2 +line_thickness, -trans_0_high - line_thickness*3 -trans_1_high), size=(trans_1_width, WG_width, trans_1_high +line_thickness))
  trans_2_sub [vacuum] = box(corner=(m_length - lT - 5*0.4mm - via_radius -0.7180mm +line_thickness, (m_width - WG_width) / 2+line_thickness, -trans_0_high - line_thickness *4-trans_1_high-trans_2_high), size=(trans_2_width, WG_width, trans_2_high + line_thickness))
  WG [copper] = box(corner=(m_length - lT - 5*0.4mm - via_radius -0.865mm -line_thickness, (m_width - WG_width) / 2, -trans_0_high -trans_1_high-trans_2_high-WG_high -line_thickness*4), size=(WG_length +2*line_thickness, WG_width +2*line_thickness, WG_high +line_thickness))
  WG_sub [vacuum] = box(corner=(m_length - lT - 5*0.4mm - via_radius -0.865mm, (m_width - WG_width) / 2 + line_thickness, -trans_0_high -trans_1_high-trans_2_high-WG_high -line_thickness*4), size=(WG_length, WG_width, WG_high))
  trans_0_sub_1 = trans_0_sub.copy()
  trans_0.subtract(trans_0_sub_1)
  trans_0_sub_2 = trans_0_sub.copy()
  trans_1.subtract(trans_0_sub_2)
  trans_1_sub_1 = trans_1_sub.copy()
  trans_1.subtract(trans_1_sub_1)
  trans_1_sub_2 = trans_1_sub.copy()
  trans_2.subtract(trans_1_sub_2)
  trans_2_sub_1 = trans_2_sub.copy()
  trans_2.subtract(trans_2_sub_1)
  trans_2_sub_2 = trans_2_sub.copy()
  WG.subtract(trans_2_sub_2)
  WG_sub_1 = WG_sub.copy()
  WG.subtract(WG_sub_1)
  Rectangle3 = rectangle(corner=(m_length, ( m_width - 5 * SL_width ) / 2, -line_thickness), y_size=5 * SL_width, z_size=8 * m_thickness)
  Rectangle4 = rectangle(corner=(m_length - lT - 5*0.4mm - via_radius -0.865mm -line_thickness, (m_width - WG_width) / 2, -trans_0_high -trans_1_high-trans_2_high-WG_high -line_thickness*4), x_size=WG_length +2*line_thickness, y_size=WG_width +2*line_thickness)
  Region [vacuum] = region(percentage_offset: +X=20, -X=20, +Y=20, -Y=20, +Z=10, -Z=10)
  waveport2 [pec] = box(corner=(m_length, ( m_width - 5 * SL_width ) / 2, -line_thickness), size=(0.1mm, 5 * SL_width, 8 * m_thickness))
  waveport1 [pec] = box(corner=(m_length - lT - 5*0.4mm - via_radius -0.865mm -line_thickness, (m_width - WG_width) / 2, -trans_0_high -trans_1_high-trans_2_high-WG_high -line_thickness*4-0.1 mm), size=(WG_length +2*line_thickness, WG_width +2*line_thickness, 0.1mm))
  Via.move(0mm, 0.15mm, 0mm)
  Via_1.move(0mm, -0.15mm, 0mm)
  Via_2 = Via.copy()
  Via_1_1 = Via_1.copy()
  via_back_9 = via_back.copy()
  medium.subtract(Via_2, Via_1_1, via_back_9)
  SL_pobe1 = rectangle(corner=(m_length - line_length, m_width/2 - SL_width/2, m_thickness), y_size=SL_width, z_size=line_thickness)
  SL_pobe3_2 = rectangle(corner=(m_length - line_length -0.1*2 mm, m_width/2 - (0.651 mm)/2, m_thickness), y_size=0.651mm, z_size=line_thickness)
  SL_pobe4_2 = rectangle(corner=(m_length - line_length - 0.1*3mm, m_width/2 - (0.713 mm)/2, m_thickness), y_size=0.713mm, z_size=line_thickness)
  SL_pobe11 = rectangle(corner=(m_length - line_length-0.1*10mm, m_width/2 - (1.344 mm)/2, m_thickness), y_size=1.344mm, z_size=line_thickness)
  SL_pobe5_2 = rectangle(corner=(m_length - line_length-0.1*4mm, m_width/2 - (0.792mm)/2, m_thickness), y_size=0.792mm, z_size=line_thickness)
  SL_pobe6_2 = rectangle(corner=(m_length - line_length -0.1*5mm, m_width/2 - (0.886 mm)/2, m_thickness), y_size=0.886mm, z_size=line_thickness)
  SL_pobe7_2 = rectangle(corner=(m_length - line_length-0.1*6mm, m_width/2 - (0.986 mm)/2, m_thickness), y_size=0.986mm, z_size=line_thickness)
  SL_pobe8_2 = rectangle(corner=(m_length - line_length-0.1*7mm, m_width/2 - (1.091 mm)/2, m_thickness), y_size=1.091mm, z_size=line_thickness)
  SL_pobe9_2 = rectangle(corner=(m_length - line_length-0.1*8mm, m_width/2 - (1.188 mm)/2, m_thickness), y_size=1.188mm, z_size=line_thickness)
  SL_pobe [copper] = rectangle(corner=(m_length - line_length-0.1*9mm, m_width/2 - (1.276 mm)/2, m_thickness), y_size=1.276mm, z_size=line_thickness)
  SL_pobe2_2 = rectangle(corner=(m_length - line_length -0.1 mm, m_width/2 - (0.605mm )/2, m_thickness), y_size=0.605mm, z_size=line_thickness)
  SL_pobe2 = rectangle(corner=(m_length - line_length -0.1 mm, m_width/2 - (0.605mm )/2, m_thickness), y_size=0.605mm, z_size=line_thickness)
  SL_pobe3 = rectangle(corner=(m_length - line_length -0.1*2 mm, m_width/2 - (0.651 mm)/2, m_thickness), y_size=0.651mm, z_size=line_thickness)
  SL_pobe4 = rectangle(corner=(m_length - line_length - 0.1*3mm, m_width/2 - (0.713 mm)/2, m_thickness), y_size=0.713mm, z_size=line_thickness)
  SL_pobe5 = rectangle(corner=(m_length - line_length-0.1*4mm, m_width/2 - (0.792mm)/2, m_thickness), y_size=0.792mm, z_size=line_thickness)
  SL_pobe6 = rectangle(corner=(m_length - line_length -0.1*5mm, m_width/2 - (0.886 mm)/2, m_thickness), y_size=0.886mm, z_size=line_thickness)
  SL_pobe7 = rectangle(corner=(m_length - line_length-0.1*6mm, m_width/2 - (0.986 mm)/2, m_thickness), y_size=0.986mm, z_size=line_thickness)
  SL_pobe8 = rectangle(corner=(m_length - line_length-0.1*7mm, m_width/2 - (1.091 mm)/2, m_thickness), y_size=1.091mm, z_size=line_thickness)
  SL_pobe9 = rectangle(corner=(m_length - line_length-0.1*8mm, m_width/2 - (1.188 mm)/2, m_thickness), y_size=1.188mm, z_size=line_thickness)
  SL_pobe10 = rectangle(corner=(m_length - line_length-0.1*9mm, m_width/2 - (1.276 mm)/2, m_thickness), y_size=1.276mm, z_size=line_thickness)
  SL_pobe1.connect(SL_pobe2)
  SL_pobe2_2.connect(SL_pobe3)
  SL_pobe4.connect(SL_pobe3_2)
  SL_pobe4_2.connect(SL_pobe5)
  SL_pobe5_2.connect(SL_pobe6)
  SL_pobe6_2.connect(SL_pobe7)
  SL_pobe7_2.connect(SL_pobe8)
  SL_pobe8_2.connect(SL_pobe9)
  SL_pobe9_2.connect(SL_pobe10)
  SL_pobe.connect(SL_pobe11)
  SL_pobe.unite(SL_pobe1, SL_pobe2_2, SL_pobe4, SL_pobe4_2, SL_pobe5_2, SL_pobe6_2, SL_pobe7_2, SL_pobe8_2, SL_pobe9_2)
  WG_hole_1 = WG_hole.copy()
  ground.subtract(WG_hole_1)
boundaries and excitations:
  Rad1: Radiation Objects=Region
  1: Wave Port Objects=Rectangle4 NumModes=1 Modes{Mode1{CharImp=Zpi}}
  2: Wave Port Objects=Rectangle3 NumModes=1 Modes{Mode1{CharImp=Zpi}}
setups:
  Setup1: HfssDriven MultipleAdaptiveFreqsSetup{Low=50GHz High=70GHz} MaxDeltaS=0.02 MaximumPasses=6 MinimumPasses=1 MinimumConvergedPasses=1 PercentRefinement=30 BasisOrder=1 PortAccuracy=2
    sweep Sweep: 50GHz to 70GHz step 1GHz; Type=Interpolating InterpTolerance=0.5 InterpMaxSolns=250 InterpUsePortImped=false PassivityErrorTolerance=0.0001
source amplitudes:
  1:1: 1W 0deg
  2:1: 0W 0deg
field plots:
  Mag_E1: E Field on Setup1 : LastAdaptive at Freq=60GHz Phase=0deg
reports:
  S Parameter Plot 1: dB(S(1,1)), dB(S(2,1)) vs Freq on Setup1 : Sweep; markers MX1 at x=6e+10
  Port Zo Plot 1: re(Zo(1:1)) vs Freq on Setup1 : Sweep
  S Parameter Plot 2: dB(S(2,1)) vs Freq on Setup1 : Sweep

design add_one_via_最佳版本 (HFSS, DrivenModal, model units mm)
variables:
  m_length = 6mm
  m_width = 5mm
  m_thickness = 0.254mm
  line_thickness = 18um
  line_length = 1mm
  line_width = 1.22mm
  patch_length = 3mm
  patch_width = 3.76mm
  lT = 2mm
  connet_width = 2mm
  connet_width2 = line_width mm
  siw_width = 2.994mm
  via_radius = 0.15mm
  h_CA = 0.15mm
  WG_width = 3.76mm
  trans_0_high = 1.415mm
  trans_0_width = 0.285mm
  trans_1_width = 0.775mm
  trans_1_high = 1.448mm
  trans_2_width = 1.552mm
  trans_2_high = 1.478mm
  WG_high = 3mm
  WG_length = (3.76/2) mm
  SL_width = 0.556mm
  SL_length = 1mm
geometry:
  medium [Rogers RO4350 (tm)] = box(corner=(0mm, 0mm, 0mm), size=(m_length, m_width, m_thickness))
  ground [copper] = box(corner=(0mm, 0mm, -line_thickness), size=(m_length, m_width, line_thickness))
  SL [copper] = box(corner=(m_length - line_length, m_width/2 - SL_width/2, m_thickness), size=(SL_length, SL_width, line_thickness))
  probe [copper] = box(corner=(m_length - lT - patch_length, m_width/2 - patch_width /2+line_thickness, m_thickness), size=(patch_length, patch_width, line_thickness))
  Via [copper] = cylinder(axis=Z, base_centre=(m_length - lT - 0.2mm, (m_width - siw_width)/2 - via_radius, 0mm), radius=via_radius, height=m_thickness)
  WG_hole [vacuum] = box(corner=(m_length - lT - 5*0.4mm - via_radius, (m_width - WG_width) / 2  + line_thickness, -line_thickness), size=(h_CA, WG_width, line_thickness))
  via_back [copper, solve inside] = cylinder(axis=Z, base_centre=(m_length - lT - 5*0.4mm - via_radius*2.2, (m_width - WG_width) / 2 + via_radius * 2, 0), radius=via_radius, height=m_thickness)
  via_back_1..via_back_8 = via_back.duplicate_along_line(step=(0mm, 0.4mm, 0mm), total=9)
  via_back.unite(via_back_1..via_back_8)
  trans_0 [copper] = box(corner=(m_length - lT - 5*0.4mm - via_radius -0.0845mm, (m_width - WG_width) / 2, -trans_0_high - line_thickness), size=(trans_0_width+2 * line_thickness, WG_width+2*line_thickness, trans_0_high))
  trans_1 [copper] = box(corner=(m_length - lT - 5*0.4mm - via_radius -0.3295mm, (m_width - WG_width) / 2, -trans_0_high - line_thickness*2 -trans_1_high), size=(trans_1_width+2 * line_thickness, WG_width+2*line_thickness, trans_1_high +line_thickness))
  trans_0_sub [vacuum] = box(corner=(m_length - lT - 5*0.4mm - via_radius -0.0845mm +line_thickness, (m_width - WG_width) / 2  +line_thickness, -trans_0_high - line_thickness*2), size=(trans_0_width, WG_width, trans_0_high + line_thickness))
  trans_2 [copper] = box(corner=(m_length - lT - 5*0.4mm - via_radius -0.7180mm, (m_width - WG_width) / 2, -trans_0_high - line_thickness *3  -trans_1_high-trans_2_high), size=(trans_2_width+2 * line_thickness, WG_width+2*line_thickness, trans_2_high +line_thickness))
  trans_1_sub [vacuum] = box(corner=(m_length - lT - 5*0.4mm - via_radius -0.3295mm +line_thickness, (m_width - WG_width) / 2 +line_thickness, -trans_0_high - line_thickness*3 -trans_1_high), size=(trans_1_width, WG_width, trans_1_high +line_thickness))
  trans_2_sub [vacuum] = box(corner=(m_length - lT - 5*0.4mm - via_radius -0.7180mm +line_thickness, (m_width - WG_width) / 2+line_thickness, -trans_0_high - line_thickness *4-trans_1_high-trans_2_high), size=(trans_2_width, WG_width, trans_2_high + line_thickness))
  WG [copper] = box(corner=(m_length - lT - 5*0.4mm - via_radius -0.865mm -line_thickness, (m_width - WG_width) / 2, -trans_0_high -trans_1_high-trans_2_high-WG_high -line_thickness*4), size=(WG_length +2*line_thickness, WG_width +2*line_thickness, WG_high +line_thickness))
  WG_sub [vacuum] = box(corner=(m_length - lT - 5*0.4mm - via_radius -0.865mm, (m_width - WG_width) / 2 + line_thickness, -trans_0_high -trans_1_high-trans_2_high-WG_high -line_thickness*4), size=(WG_length, WG_width, WG_high))
  Rectangle3 = rectangle(corner=(m_length, ( m_width - 5 * SL_width ) / 2, -line_thickness), y_size=5 * SL_width, z_size=8 * m_thickness)
  Rectangle4 = rectangle(corner=(m_length - lT - 5*0.4mm - via_radius -0.865mm -line_thickness, (m_width - WG_width) / 2, -trans_0_high -trans_1_high-trans_2_high-WG_high -line_thickness*4), x_size=WG_length +2*line_thickness, y_size=WG_width +2*line_thickness)
  Region [vacuum] = region(percentage_offset: +X=20, -X=20, +Y=20, -Y=20, +Z=10, -Z=10)
  waveport2 [pec] = box(corner=(m_length, ( m_width - 5 * SL_width ) / 2, -line_thickness), size=(0.1mm, 5 * SL_width, 8 * m_thickness))
  waveport1 [pec] = box(corner=(m_length - lT - 5*0.4mm - via_radius -0.865mm -line_thickness, (m_width - WG_width) / 2, -trans_0_high -trans_1_high-trans_2_high-WG_high -line_thickness*4-0.1 mm), size=(WG_length +2*line_thickness, WG_width +2*line_thickness, 0.1mm))
  Via.move(0mm, 0.15mm, 0mm)
  SL_pobe1 = rectangle(corner=(m_length - line_length, m_width/2 - SL_width/2, m_thickness), y_size=SL_width, z_size=line_thickness)
  SL_pobe3_2 = rectangle(corner=(m_length - line_length -0.1*2 mm, m_width/2 - (0.651 mm)/2, m_thickness), y_size=0.651mm, z_size=line_thickness)
  SL_pobe4_2 = rectangle(corner=(m_length - line_length - 0.1*3mm, m_width/2 - (0.713 mm)/2, m_thickness), y_size=0.713mm, z_size=line_thickness)
  SL_pobe11 = rectangle(corner=(m_length - line_length-0.1*10mm, m_width/2 - (1.344 mm)/2, m_thickness), y_size=1.344mm, z_size=line_thickness)
  SL_pobe5_2 = rectangle(corner=(m_length - line_length-0.1*4mm, m_width/2 - (0.792mm)/2, m_thickness), y_size=0.792mm, z_size=line_thickness)
  SL_pobe6_2 = rectangle(corner=(m_length - line_length -0.1*5mm, m_width/2 - (0.886 mm)/2, m_thickness), y_size=0.886mm, z_size=line_thickness)
  SL_pobe7_2 = rectangle(corner=(m_length - line_length-0.1*6mm, m_width/2 - (0.986 mm)/2, m_thickness), y_size=0.986mm, z_size=line_thickness)
  SL_pobe8_2 = rectangle(corner=(m_length - line_length-0.1*7mm, m_width/2 - (1.091 mm)/2, m_thickness), y_size=1.091mm, z_size=line_thickness)
  SL_pobe9_2 = rectangle(corner=(m_length - line_length-0.1*8mm, m_width/2 - (1.188 mm)/2, m_thickness), y_size=1.188mm, z_size=line_thickness)
  SL_pobe [copper] = rectangle(corner=(m_length - line_length-0.1*9mm, m_width/2 - (1.276 mm)/2, m_thickness), y_size=1.276mm, z_size=line_thickness)
  SL_pobe2_2 = rectangle(corner=(m_length - line_length -0.1 mm, m_width/2 - (0.605mm )/2, m_thickness), y_size=0.605mm, z_size=line_thickness)
  SL_pobe2 = rectangle(corner=(m_length - line_length -0.1 mm, m_width/2 - (0.605mm )/2, m_thickness), y_size=0.605mm, z_size=line_thickness)
  SL_pobe3 = rectangle(corner=(m_length - line_length -0.1*2 mm, m_width/2 - (0.651 mm)/2, m_thickness), y_size=0.651mm, z_size=line_thickness)
  SL_pobe4 = rectangle(corner=(m_length - line_length - 0.1*3mm, m_width/2 - (0.713 mm)/2, m_thickness), y_size=0.713mm, z_size=line_thickness)
  SL_pobe5 = rectangle(corner=(m_length - line_length-0.1*4mm, m_width/2 - (0.792mm)/2, m_thickness), y_size=0.792mm, z_size=line_thickness)
  SL_pobe6 = rectangle(corner=(m_length - line_length -0.1*5mm, m_width/2 - (0.886 mm)/2, m_thickness), y_size=0.886mm, z_size=line_thickness)
  SL_pobe7 = rectangle(corner=(m_length - line_length-0.1*6mm, m_width/2 - (0.986 mm)/2, m_thickness), y_size=0.986mm, z_size=line_thickness)
  SL_pobe8 = rectangle(corner=(m_length - line_length-0.1*7mm, m_width/2 - (1.091 mm)/2, m_thickness), y_size=1.091mm, z_size=line_thickness)
  SL_pobe9 = rectangle(corner=(m_length - line_length-0.1*8mm, m_width/2 - (1.188 mm)/2, m_thickness), y_size=1.188mm, z_size=line_thickness)
  SL_pobe10 = rectangle(corner=(m_length - line_length-0.1*9mm, m_width/2 - (1.276 mm)/2, m_thickness), y_size=1.276mm, z_size=line_thickness)
  SL_pobe1.connect(SL_pobe2)
  SL_pobe2_2.connect(SL_pobe3)
  SL_pobe4.connect(SL_pobe3_2)
  SL_pobe4_2.connect(SL_pobe5)
  SL_pobe5_2.connect(SL_pobe6)
  SL_pobe6_2.connect(SL_pobe7)
  SL_pobe7_2.connect(SL_pobe8)
  SL_pobe8_2.connect(SL_pobe9)
  SL_pobe9_2.connect(SL_pobe10)
  SL_pobe.connect(SL_pobe11)
  SL_pobe.unite(SL_pobe1, SL_pobe2_2, SL_pobe4, SL_pobe4_2, SL_pobe5_2, SL_pobe6_2, SL_pobe7_2, SL_pobe8_2, SL_pobe9_2)
  [via_back, WG_hole, WG_sub, Rectangle4, trans_1, trans_2, trans_0, trans_0_sub, trans_1_sub, trans_2_sub].move(-0.4mm, 0mm, 0mm)
  Via_1..Via_5 = Via.duplicate_along_line(step=(-0.4mm, 0mm, 0mm), total=6)
  Via.unite(Via_1..Via_5)
  Via_6 [copper] = Via.duplicate_mirror(point=(2.465mm, 2.518mm, -4.413mm), normal=(0mm, 1mm, 0mm))
  WG_hole_1 = WG_hole.copy()
  ground.subtract(WG_hole_1)
  Via_7 = Via.copy()
  Via_6_1 = Via_6.copy()
  via_back_9 = via_back.copy()
  medium.subtract(Via_7, Via_6_1, via_back_9)
  [WG, waveport1].move(-0.4mm, 0mm, 0mm)
  trans_0_sub_1 = trans_0_sub.copy()
  trans_1_sub_1 = trans_1_sub.copy()
  trans_2_sub_1 = trans_2_sub.copy()
  WG_sub_1 = WG_sub.copy()
  trans_0.subtract(trans_0_sub_1, trans_1_sub_1, trans_2_sub_1, WG_sub_1)
  trans_0_sub_2 = trans_0_sub.copy()
  trans_1_sub_2 = trans_1_sub.copy()
  trans_2_sub_2 = trans_2_sub.copy()
  WG_sub_2 = WG_sub.copy()
  trans_1.subtract(trans_0_sub_2, trans_1_sub_2, trans_2_sub_2, WG_sub_2)
  trans_0_sub_3 = trans_0_sub.copy()
  trans_1_sub_3 = trans_1_sub.copy()
  trans_2_sub_3 = trans_2_sub.copy()
  WG_sub_3 = WG_sub.copy()
  trans_2.subtract(trans_0_sub_3, trans_1_sub_3, trans_2_sub_3, WG_sub_3)
  trans_0_sub_4 = trans_0_sub.copy()
  trans_1_sub_4 = trans_1_sub.copy()
  trans_2_sub_4 = trans_2_sub.copy()
  WG_sub_4 = WG_sub.copy()
  WG.subtract(trans_0_sub_4, trans_1_sub_4, trans_2_sub_4, WG_sub_4)
boundaries and excitations:
  Rad1: Radiation Objects=Region
  1: Wave Port Objects=Rectangle4 NumModes=1 Modes{Mode1{IntLine{middle of WG_sub.edge(5 of 12) -> middle of WG_sub.edge(7 of 12)} CharImp=Zpv}}
  2: Wave Port Objects=Rectangle3 NumModes=1 Modes{Mode1{IntLine{middle of Rectangle3.edge(z at corner) -> middle of Rectangle3.edge(z opposite corner)} CharImp=Zpi}}
setups:
  Setup1: HfssDriven MultipleAdaptiveFreqsSetup{Low=50GHz High=70GHz} MaxDeltaS=0.02 MaximumPasses=6 MinimumPasses=1 MinimumConvergedPasses=1 PercentRefinement=30 BasisOrder=1 PortAccuracy=2
    sweep Sweep: 50GHz to 70GHz step 1GHz; Type=Interpolating InterpTolerance=0.5 InterpMaxSolns=250 InterpUsePortImped=false PassivityErrorTolerance=0.0001
source amplitudes:
  1:1: 1W 0deg
  2:1: 0W 0deg
field plots:
  Mag_E1: E Field on Setup1 : LastAdaptive at Freq=60GHz Phase=0deg
reports:
  S Parameter Plot 1: dB(S(1,1)), dB(S(2,1)) vs Freq on Setup1 : Sweep; markers MX1 at x=6e+10
  Port Zo Plot 1: re(Zo(1:1)) vs Freq on Setup1 : Sweep; markers MX1 at x=6e+10
  S Parameter Plot 2: dB(S(2,1)) vs Freq on Setup1 : Sweep

design add_one_via_測試距離trans (HFSS, DrivenModal, model units mm)
variables:
  m_length = 6mm
  m_width = 5mm
  m_thickness = 0.254mm
  line_thickness = 18um
  line_length = 1mm
  line_width = 1.22mm
  patch_length = 3mm
  patch_width = 3.76mm
  lT = 2mm
  connet_width = 2mm
  connet_width2 = line_width mm
  siw_width = 2.994mm
  via_radius = 0.15mm
  h_CA = 0.15mm
  WG_width = 3.76mm
  trans_0_high = 1.415mm
  trans_0_width = 0.578mm
  trans_1_width = 1.007mm
  trans_1_high = 1.448mm
  trans_2_width = 1.45mm
  trans_2_high = 1.478mm
  WG_high = 3mm
  WG_length = (3.76/2) mm
  SL_width = 0.556mm
  SL_length = 1mm
geometry:
  medium [Rogers RO4350 (tm)] = box(corner=(0mm, 0mm, 0mm), size=(m_length, m_width, m_thickness))
  ground [copper] = box(corner=(0mm, 0mm, -line_thickness), size=(m_length, m_width, line_thickness))
  SL [copper] = box(corner=(m_length - line_length, m_width/2 - SL_width/2, m_thickness), size=(SL_length, SL_width, line_thickness))
  probe [copper] = box(corner=(m_length - lT - patch_length, m_width/2 - patch_width /2+line_thickness, m_thickness), size=(patch_length, patch_width, line_thickness))
  Via [copper] = cylinder(axis=Z, base_centre=(m_length - lT - 0.2mm, (m_width - siw_width)/2 - via_radius, 0mm), radius=via_radius, height=m_thickness)
  WG_hole [vacuum] = box(corner=(m_length - lT - 5*0.4mm - via_radius, (m_width - WG_width) / 2  + line_thickness, -line_thickness), size=(h_CA, WG_width, line_thickness))
  via_back [copper, solve inside] = cylinder(axis=Z, base_centre=(m_length - lT - 5*0.4mm - via_radius*2.2, (m_width - WG_width) / 2 + via_radius * 2, 0), radius=via_radius, height=m_thickness)
  via_back_1..via_back_8 = via_back.duplicate_along_line(step=(0mm, 0.4mm, 0mm), total=9)
  via_back.unite(via_back_1..via_back_8)
  trans_0 [copper] = box(corner=(m_length - lT - 5*0.4mm - via_radius +(h_CA-trans_0_width)/2 - line_thickness, (m_width - WG_width) / 2, -trans_0_high - line_thickness), size=(trans_0_width+2 * line_thickness, WG_width+2*line_thickness, trans_0_high))
  trans_1 [copper] = box(corner=(m_length - lT - 5*0.4mm - via_radius +(h_CA-trans_1_width)/2-line_thickness, (m_width - WG_width) / 2, -trans_0_high - line_thickness*2 -trans_1_high), size=(trans_1_width+2 * line_thickness, WG_width+2*line_thickness, trans_1_high +line_thickness))
  trans_0_sub [vacuum] = box(corner=(m_length - lT - 5*0.4mm - via_radius +(h_CA-trans_0_width)/2, (m_width - WG_width) / 2  +line_thickness, -trans_0_high - line_thickness*2), size=(trans_0_width, WG_width, trans_0_high + line_thickness))
  trans_2 [copper] = box(corner=(m_length - lT - 5*0.4mm - via_radius +(h_CA-trans_2_width)/2-line_thickness, (m_width - WG_width) / 2, -trans_0_high - line_thickness *3  -trans_1_high-trans_2_high), size=(trans_2_width+2 * line_thickness, WG_width+2*line_thickness, trans_2_high +line_thickness))
  trans_1_sub [vacuum] = box(corner=(m_length - lT - 5*0.4mm - via_radius +(h_CA-trans_1_width)/2, (m_width - WG_width) / 2 +line_thickness, -trans_0_high - line_thickness*3 -trans_1_high), size=(trans_1_width, WG_width, trans_1_high +line_thickness))
  trans_2_sub [vacuum] = box(corner=(m_length - lT - 5*0.4mm - via_radius +(h_CA-trans_2_width)/2, (m_width - WG_width) / 2+line_thickness, -trans_0_high - line_thickness *4-trans_1_high-trans_2_high), size=(trans_2_width, WG_width, trans_2_high + line_thickness))
  WG [copper] = box(corner=(m_length - lT - 5*0.4mm - via_radius +(h_CA-WG_length)/2-line_thickness, (m_width - WG_width) / 2, -trans_0_high -trans_1_high-trans_2_high-WG_high -line_thickness*4), size=(WG_length +2*line_thickness, WG_width +2*line_thickness, WG_high +line_thickness))
  WG_sub [vacuum] = box(corner=(m_length - lT - 5*0.4mm - via_radius +(h_CA-WG_length)/2, (m_width - WG_width) / 2 + line_thickness, -trans_0_high -trans_1_high-trans_2_high-WG_high -line_thickness*4), size=(WG_length, WG_width, WG_high))
  Rectangle3 = rectangle(corner=(m_length, ( m_width - 5 * SL_width ) / 2, -line_thickness), y_size=5 * SL_width, z_size=8 * m_thickness)
  Rectangle4 = rectangle(corner=(m_length - lT - 5*0.4mm - via_radius -0.865mm -line_thickness, (m_width - WG_width) / 2, -trans_0_high -trans_1_high-trans_2_high-WG_high -line_thickness*4), x_size=WG_length +2*line_thickness, y_size=WG_width +2*line_thickness)
  Region [vacuum] = region(percentage_offset: +X=20, -X=20, +Y=20, -Y=20, +Z=10, -Z=10)
  waveport2 [pec] = box(corner=(m_length, ( m_width - 5 * SL_width ) / 2, -line_thickness), size=(0.1mm, 5 * SL_width, 8 * m_thickness))
  waveport1 [pec] = box(corner=(m_length - lT - 5*0.4mm - via_radius -0.865mm -line_thickness, (m_width - WG_width) / 2, -trans_0_high -trans_1_high-trans_2_high-WG_high -line_thickness*4-0.1 mm), size=(WG_length +2*line_thickness, WG_width +2*line_thickness, 0.1mm))
  Via.move(0mm, 0.15mm, 0mm)
  SL_pobe1 = rectangle(corner=(m_length - line_length, m_width/2 - SL_width/2, m_thickness), y_size=SL_width, z_size=line_thickness)
  SL_pobe3_2 = rectangle(corner=(m_length - line_length -0.1*2 mm, m_width/2 - (0.651 mm)/2, m_thickness), y_size=0.651mm, z_size=line_thickness)
  SL_pobe4_2 = rectangle(corner=(m_length - line_length - 0.1*3mm, m_width/2 - (0.713 mm)/2, m_thickness), y_size=0.713mm, z_size=line_thickness)
  SL_pobe11 = rectangle(corner=(m_length - line_length-0.1*10mm, m_width/2 - (1.344 mm)/2, m_thickness), y_size=1.344mm, z_size=line_thickness)
  SL_pobe5_2 = rectangle(corner=(m_length - line_length-0.1*4mm, m_width/2 - (0.792mm)/2, m_thickness), y_size=0.792mm, z_size=line_thickness)
  SL_pobe6_2 = rectangle(corner=(m_length - line_length -0.1*5mm, m_width/2 - (0.886 mm)/2, m_thickness), y_size=0.886mm, z_size=line_thickness)
  SL_pobe7_2 = rectangle(corner=(m_length - line_length-0.1*6mm, m_width/2 - (0.986 mm)/2, m_thickness), y_size=0.986mm, z_size=line_thickness)
  SL_pobe8_2 = rectangle(corner=(m_length - line_length-0.1*7mm, m_width/2 - (1.091 mm)/2, m_thickness), y_size=1.091mm, z_size=line_thickness)
  SL_pobe9_2 = rectangle(corner=(m_length - line_length-0.1*8mm, m_width/2 - (1.188 mm)/2, m_thickness), y_size=1.188mm, z_size=line_thickness)
  SL_pobe [copper] = rectangle(corner=(m_length - line_length-0.1*9mm, m_width/2 - (1.276 mm)/2, m_thickness), y_size=1.276mm, z_size=line_thickness)
  SL_pobe2_2 = rectangle(corner=(m_length - line_length -0.1 mm, m_width/2 - (0.605mm )/2, m_thickness), y_size=0.605mm, z_size=line_thickness)
  SL_pobe2 = rectangle(corner=(m_length - line_length -0.1 mm, m_width/2 - (0.605mm )/2, m_thickness), y_size=0.605mm, z_size=line_thickness)
  SL_pobe3 = rectangle(corner=(m_length - line_length -0.1*2 mm, m_width/2 - (0.651 mm)/2, m_thickness), y_size=0.651mm, z_size=line_thickness)
  SL_pobe4 = rectangle(corner=(m_length - line_length - 0.1*3mm, m_width/2 - (0.713 mm)/2, m_thickness), y_size=0.713mm, z_size=line_thickness)
  SL_pobe5 = rectangle(corner=(m_length - line_length-0.1*4mm, m_width/2 - (0.792mm)/2, m_thickness), y_size=0.792mm, z_size=line_thickness)
  SL_pobe6 = rectangle(corner=(m_length - line_length -0.1*5mm, m_width/2 - (0.886 mm)/2, m_thickness), y_size=0.886mm, z_size=line_thickness)
  SL_pobe7 = rectangle(corner=(m_length - line_length-0.1*6mm, m_width/2 - (0.986 mm)/2, m_thickness), y_size=0.986mm, z_size=line_thickness)
  SL_pobe8 = rectangle(corner=(m_length - line_length-0.1*7mm, m_width/2 - (1.091 mm)/2, m_thickness), y_size=1.091mm, z_size=line_thickness)
  SL_pobe9 = rectangle(corner=(m_length - line_length-0.1*8mm, m_width/2 - (1.188 mm)/2, m_thickness), y_size=1.188mm, z_size=line_thickness)
  SL_pobe10 = rectangle(corner=(m_length - line_length-0.1*9mm, m_width/2 - (1.276 mm)/2, m_thickness), y_size=1.276mm, z_size=line_thickness)
  SL_pobe1.connect(SL_pobe2)
  SL_pobe2_2.connect(SL_pobe3)
  SL_pobe4.connect(SL_pobe3_2)
  SL_pobe4_2.connect(SL_pobe5)
  SL_pobe5_2.connect(SL_pobe6)
  SL_pobe6_2.connect(SL_pobe7)
  SL_pobe7_2.connect(SL_pobe8)
  SL_pobe8_2.connect(SL_pobe9)
  SL_pobe9_2.connect(SL_pobe10)
  SL_pobe.connect(SL_pobe11)
  SL_pobe.unite(SL_pobe1, SL_pobe2_2, SL_pobe4, SL_pobe4_2, SL_pobe5_2, SL_pobe6_2, SL_pobe7_2, SL_pobe8_2, SL_pobe9_2)
  [via_back, WG_hole, WG_sub, Rectangle4, trans_1, trans_2, trans_0, trans_0_sub, trans_1_sub, trans_2_sub].move(-0.4mm, 0mm, 0mm)
  Via_1..Via_5 = Via.duplicate_along_line(step=(-0.4mm, 0mm, 0mm), total=6)
  Via.unite(Via_1..Via_5)
  Via_6 [copper] = Via.duplicate_mirror(point=(2.465mm, 2.518mm, -4.413mm), normal=(0mm, 1mm, 0mm))
  WG_hole_1 = WG_hole.copy()
  ground.subtract(WG_hole_1)
  Via_7 = Via.copy()
  Via_6_1 = Via_6.copy()
  via_back_9 = via_back.copy()
  medium.subtract(Via_7, Via_6_1, via_back_9)
  [WG, waveport1].move(-0.4mm, 0mm, 0mm)
  trans_0_sub_1 = trans_0_sub.copy()
  trans_1_sub_1 = trans_1_sub.copy()
  trans_2_sub_1 = trans_2_sub.copy()
  WG_sub_1 = WG_sub.copy()
  trans_0.subtract(trans_0_sub_1, trans_1_sub_1, trans_2_sub_1, WG_sub_1)
  trans_0_sub_2 = trans_0_sub.copy()
  trans_1_sub_2 = trans_1_sub.copy()
  trans_2_sub_2 = trans_2_sub.copy()
  WG_sub_2 = WG_sub.copy()
  trans_1.subtract(trans_0_sub_2, trans_1_sub_2, trans_2_sub_2, WG_sub_2)
  trans_0_sub_3 = trans_0_sub.copy()
  trans_1_sub_3 = trans_1_sub.copy()
  trans_2_sub_3 = trans_2_sub.copy()
  WG_sub_3 = WG_sub.copy()
  trans_2.subtract(trans_0_sub_3, trans_1_sub_3, trans_2_sub_3, WG_sub_3)
  trans_0_sub_4 = trans_0_sub.copy()
  trans_1_sub_4 = trans_1_sub.copy()
  trans_2_sub_4 = trans_2_sub.copy()
  WG_sub_4 = WG_sub.copy()
  WG.subtract(trans_0_sub_4, trans_1_sub_4, trans_2_sub_4, WG_sub_4)
boundaries and excitations:
  Rad1: Radiation Objects=Region
  1: Wave Port Objects=Rectangle4 NumModes=1 Modes{Mode1{IntLine{middle of WG_sub.edge(5 of 12) -> middle of WG_sub.edge(7 of 12)} CharImp=Zpv}}
  2: Wave Port Objects=Rectangle3 NumModes=1 Modes{Mode1{IntLine{middle of Rectangle3.edge(z at corner) -> middle of Rectangle3.edge(z opposite corner)} CharImp=Zpi}}
setups:
  Setup1: HfssDriven MultipleAdaptiveFreqsSetup{Low=50GHz High=70GHz} MaxDeltaS=0.02 MaximumPasses=6 MinimumPasses=1 MinimumConvergedPasses=1 PercentRefinement=30 BasisOrder=1 PortAccuracy=2
    sweep Sweep: 50GHz to 70GHz step 1GHz; Type=Interpolating InterpTolerance=0.5 InterpMaxSolns=250 InterpUsePortImped=false PassivityErrorTolerance=0.0001
source amplitudes:
  1:1: 1W 0deg
  2:1: 0W 0deg
optimetrics:
  ParametricSetup1: Parametric Sim._Setups=[Setup1]
    sweep trans_0_high: LINC 0.7075mm 2.1225mm 5
    sweep trans_1_high: LINC 0.724mm 2.172mm 5
    sweep trans_1_width: LINC 0.5035mm 1.5105mm 5
    sweep trans_2_width: LINC 0.725mm 2.175mm 5
    sweep trans_0_width: LINC 0.289mm 0.867mm 5
    sweep trans_2_high: LINC 0.739mm 2.217mm 5
field plots:
  Mag_E1: E Field on Setup1 : LastAdaptive at Freq=60GHz Phase=0deg
reports:
  S Parameter Plot 1: dB(S(1,1)), dB(S(2,1)) vs Freq on Setup1 : Sweep; markers MX1 at x=6e+10
  Port Zo Plot 1: re(Zo(1:1)) vs Freq on Setup1 : Sweep; markers MX1 at x=6e+10
  S Parameter Plot 2: dB(S(2,1)) vs Freq on Setup1 : Sweep

design add_one_via_包裹步階 (HFSS, DrivenModal, model units mm)
variables:
  m_length = 6mm
  m_width = 5mm
  m_thickness = 0.254mm
  line_thickness = 18um
  line_length = 1mm
  line_width = 1.22mm
  patch_length = 3mm
  patch_width = 3.76mm
  lT = 2mm
  connet_width = 2mm
  connet_width2 = line_width mm
  siw_width = 2.994mm
  via_radius = 0.15mm
  h_CA = 0.15mm
  WG_width = 3.76mm
  trans_0_high = 1.415mm
  trans_0_width = 0.285mm
  trans_1_width = 0.775mm
  trans_1_high = 1.448mm
  trans_2_width = 1.552mm
  trans_2_high = 1.478mm
  WG_high = 3mm
  WG_length = (3.76/2) mm
  SL_width = 0.556mm
  SL_length = 1mm
geometry:
  medium [Rogers RO4350 (tm)] = box(corner=(0mm, 0mm, 0mm), size=(m_length, m_width, m_thickness))
  ground [copper] = box(corner=(0mm, 0mm, -line_thickness), size=(m_length, m_width, line_thickness))
  SL [copper] = box(corner=(m_length - line_length, m_width/2 - SL_width/2, m_thickness), size=(SL_length, SL_width, line_thickness))
  probe [copper] = box(corner=(m_length - lT - patch_length, m_width/2 - patch_width /2+line_thickness, m_thickness), size=(patch_length, patch_width, line_thickness))
  Via [copper] = cylinder(axis=Z, base_centre=(m_length - lT - 0.2mm, (m_width - siw_width)/2 - via_radius, 0mm), radius=via_radius, height=m_thickness)
  WG_hole [vacuum] = box(corner=(m_length - lT - 5*0.4mm - via_radius, (m_width - WG_width) / 2  + line_thickness, -line_thickness), size=(h_CA, WG_width, line_thickness))
  via_back [copper, solve inside] = cylinder(axis=Z, base_centre=(m_length - lT - 5*0.4mm - via_radius*2.2, (m_width - WG_width) / 2 + via_radius * 2, 0), radius=via_radius, height=m_thickness)
  via_back_1..via_back_8 = via_back.duplicate_along_line(step=(0mm, 0.4mm, 0mm), total=9)
  via_back.unite(via_back_1..via_back_8)
  trans_0 [copper] = box(corner=(m_length - lT - 5*0.4mm - via_radius -0.0845mm, (m_width - WG_width) / 2, -trans_0_high - line_thickness), size=(trans_0_width+2 * line_thickness, WG_width+2*line_thickness, trans_0_high))
  trans_1 [copper] = box(corner=(m_length - lT - 5*0.4mm - via_radius -0.3295mm, (m_width - WG_width) / 2, -trans_0_high - line_thickness*2 -trans_1_high), size=(trans_1_width+2 * line_thickness, WG_width+2*line_thickness, trans_1_high +line_thickness))
  trans_0_sub [vacuum] = box(corner=(m_length - lT - 5*0.4mm - via_radius -0.0845mm +line_thickness, (m_width - WG_width) / 2  +line_thickness, -trans_0_high - line_thickness*2), size=(trans_0_width, WG_width, trans_0_high + line_thickness))
  trans_2 [copper] = box(corner=(m_length - lT - 5*0.4mm - via_radius -0.7180mm, (m_width - WG_width) / 2, -trans_0_high - line_thickness *3  -trans_1_high-trans_2_high), size=(trans_2_width+2 * line_thickness, WG_width+2*line_thickness, trans_2_high +line_thickness))
  trans_1_sub [vacuum] = box(corner=(m_length - lT - 5*0.4mm - via_radius -0.3295mm +line_thickness, (m_width - WG_width) / 2 +line_thickness, -trans_0_high - line_thickness*3 -trans_1_high), size=(trans_1_width, WG_width, trans_1_high +line_thickness))
  trans_2_sub [vacuum] = box(corner=(m_length - lT - 5*0.4mm - via_radius -0.7180mm +line_thickness, (m_width - WG_width) / 2+line_thickness, -trans_0_high - line_thickness *4-trans_1_high-trans_2_high), size=(trans_2_width, WG_width, trans_2_high + line_thickness))
  WG [copper] = box(corner=(m_length - lT - 5*0.4mm - via_radius -0.865mm -line_thickness, (m_width - WG_width) / 2, -trans_0_high -trans_1_high-trans_2_high-WG_high -line_thickness*4), size=(WG_length +2*line_thickness, WG_width +2*line_thickness, WG_high +line_thickness*3+trans_0_high+trans_1_high+trans_2_high))
  WG_sub [vacuum] = box(corner=(m_length - lT - 5*0.4mm - via_radius -0.865mm, (m_width - WG_width) / 2 + line_thickness, -trans_0_high -trans_1_high-trans_2_high-WG_high -line_thickness*4), size=(WG_length, WG_width, WG_high))
  Rectangle3 = rectangle(corner=(m_length, ( m_width - 5 * SL_width ) / 2, -line_thickness), y_size=5 * SL_width, z_size=8 * m_thickness)
  Rectangle4 = rectangle(corner=(m_length - lT - 5*0.4mm - via_radius -0.865mm -line_thickness, (m_width - WG_width) / 2, -trans_0_high -trans_1_high-trans_2_high-WG_high -line_thickness*4), x_size=WG_length +2*line_thickness, y_size=WG_width +2*line_thickness)
  Region [vacuum] = region(percentage_offset: +X=20, -X=20, +Y=20, -Y=20, +Z=10, -Z=10)
  waveport2 [pec] = box(corner=(m_length, ( m_width - 5 * SL_width ) / 2, -line_thickness), size=(0.1mm, 5 * SL_width, 8 * m_thickness))
  waveport1 [pec] = box(corner=(m_length - lT - 5*0.4mm - via_radius -0.865mm -line_thickness, (m_width - WG_width) / 2, -trans_0_high -trans_1_high-trans_2_high-WG_high -line_thickness*4-0.1 mm), size=(WG_length +2*line_thickness, WG_width +2*line_thickness, 0.1mm))
  Via.move(0mm, 0.15mm, 0mm)
  SL_pobe1 = rectangle(corner=(m_length - line_length, m_width/2 - SL_width/2, m_thickness), y_size=SL_width, z_size=line_thickness)
  SL_pobe3_2 = rectangle(corner=(m_length - line_length -0.1*2 mm, m_width/2 - (0.651 mm)/2, m_thickness), y_size=0.651mm, z_size=line_thickness)
  SL_pobe4_2 = rectangle(corner=(m_length - line_length - 0.1*3mm, m_width/2 - (0.713 mm)/2, m_thickness), y_size=0.713mm, z_size=line_thickness)
  SL_pobe11 = rectangle(corner=(m_length - line_length-0.1*10mm, m_width/2 - (1.344 mm)/2, m_thickness), y_size=1.344mm, z_size=line_thickness)
  SL_pobe5_2 = rectangle(corner=(m_length - line_length-0.1*4mm, m_width/2 - (0.792mm)/2, m_thickness), y_size=0.792mm, z_size=line_thickness)
  SL_pobe6_2 = rectangle(corner=(m_length - line_length -0.1*5mm, m_width/2 - (0.886 mm)/2, m_thickness), y_size=0.886mm, z_size=line_thickness)
  SL_pobe7_2 = rectangle(corner=(m_length - line_length-0.1*6mm, m_width/2 - (0.986 mm)/2, m_thickness), y_size=0.986mm, z_size=line_thickness)
  SL_pobe8_2 = rectangle(corner=(m_length - line_length-0.1*7mm, m_width/2 - (1.091 mm)/2, m_thickness), y_size=1.091mm, z_size=line_thickness)
  SL_pobe9_2 = rectangle(corner=(m_length - line_length-0.1*8mm, m_width/2 - (1.188 mm)/2, m_thickness), y_size=1.188mm, z_size=line_thickness)
  SL_pobe [copper] = rectangle(corner=(m_length - line_length-0.1*9mm, m_width/2 - (1.276 mm)/2, m_thickness), y_size=1.276mm, z_size=line_thickness)
  SL_pobe2_2 = rectangle(corner=(m_length - line_length -0.1 mm, m_width/2 - (0.605mm )/2, m_thickness), y_size=0.605mm, z_size=line_thickness)
  SL_pobe2 = rectangle(corner=(m_length - line_length -0.1 mm, m_width/2 - (0.605mm )/2, m_thickness), y_size=0.605mm, z_size=line_thickness)
  SL_pobe3 = rectangle(corner=(m_length - line_length -0.1*2 mm, m_width/2 - (0.651 mm)/2, m_thickness), y_size=0.651mm, z_size=line_thickness)
  SL_pobe4 = rectangle(corner=(m_length - line_length - 0.1*3mm, m_width/2 - (0.713 mm)/2, m_thickness), y_size=0.713mm, z_size=line_thickness)
  SL_pobe5 = rectangle(corner=(m_length - line_length-0.1*4mm, m_width/2 - (0.792mm)/2, m_thickness), y_size=0.792mm, z_size=line_thickness)
  SL_pobe6 = rectangle(corner=(m_length - line_length -0.1*5mm, m_width/2 - (0.886 mm)/2, m_thickness), y_size=0.886mm, z_size=line_thickness)
  SL_pobe7 = rectangle(corner=(m_length - line_length-0.1*6mm, m_width/2 - (0.986 mm)/2, m_thickness), y_size=0.986mm, z_size=line_thickness)
  SL_pobe8 = rectangle(corner=(m_length - line_length-0.1*7mm, m_width/2 - (1.091 mm)/2, m_thickness), y_size=1.091mm, z_size=line_thickness)
  SL_pobe9 = rectangle(corner=(m_length - line_length-0.1*8mm, m_width/2 - (1.188 mm)/2, m_thickness), y_size=1.188mm, z_size=line_thickness)
  SL_pobe10 = rectangle(corner=(m_length - line_length-0.1*9mm, m_width/2 - (1.276 mm)/2, m_thickness), y_size=1.276mm, z_size=line_thickness)
  SL_pobe1.connect(SL_pobe2)
  SL_pobe2_2.connect(SL_pobe3)
  SL_pobe4.connect(SL_pobe3_2)
  SL_pobe4_2.connect(SL_pobe5)
  SL_pobe5_2.connect(SL_pobe6)
  SL_pobe6_2.connect(SL_pobe7)
  SL_pobe7_2.connect(SL_pobe8)
  SL_pobe8_2.connect(SL_pobe9)
  SL_pobe9_2.connect(SL_pobe10)
  SL_pobe.connect(SL_pobe11)
  SL_pobe.unite(SL_pobe1, SL_pobe2_2, SL_pobe4, SL_pobe4_2, SL_pobe5_2, SL_pobe6_2, SL_pobe7_2, SL_pobe8_2, SL_pobe9_2)
  [via_back, WG_hole, WG_sub, Rectangle4, trans_1, trans_2, trans_0, trans_0_sub, trans_1_sub, trans_2_sub].move(-0.4mm, 0mm, 0mm)
  Via_1..Via_5 = Via.duplicate_along_line(step=(-0.4mm, 0mm, 0mm), total=6)
  Via.unite(Via_1..Via_5)
  Via_6 [copper] = Via.duplicate_mirror(point=(2.465mm, 2.518mm, -4.413mm), normal=(0mm, 1mm, 0mm))
  WG_hole_1 = WG_hole.copy()
  ground.subtract(WG_hole_1)
  Via_7 = Via.copy()
  Via_6_1 = Via_6.copy()
  via_back_9 = via_back.copy()
  medium.subtract(Via_7, Via_6_1, via_back_9)
  [WG, waveport1].move(-0.4mm, 0mm, 0mm)
  trans_0_sub_1 = trans_0_sub.copy()
  trans_1_sub_1 = trans_1_sub.copy()
  trans_2_sub_1 = trans_2_sub.copy()
  WG_sub_1 = WG_sub.copy()
  trans_0.subtract(trans_0_sub_1, trans_1_sub_1, trans_2_sub_1, WG_sub_1)
  trans_0_sub_2 = trans_0_sub.copy()
  trans_1_sub_2 = trans_1_sub.copy()
  trans_2_sub_2 = trans_2_sub.copy()
  WG_sub_2 = WG_sub.copy()
  trans_1.subtract(trans_0_sub_2, trans_1_sub_2, trans_2_sub_2, WG_sub_2)
  trans_0_sub_3 = trans_0_sub.copy()
  trans_1_sub_3 = trans_1_sub.copy()
  trans_2_sub_3 = trans_2_sub.copy()
  WG_sub_3 = WG_sub.copy()
  trans_2.subtract(trans_0_sub_3, trans_1_sub_3, trans_2_sub_3, WG_sub_3)
  trans_0_sub_4 = trans_0_sub.copy()
  trans_1_sub_4 = trans_1_sub.copy()
  trans_2_sub_4 = trans_2_sub.copy()
  WG_sub_4 = WG_sub.copy()
  WG.subtract(trans_0_sub_4, trans_1_sub_4, trans_2_sub_4, WG_sub_4)
boundaries and excitations:
  Rad1: Radiation Objects=Region
  1: Wave Port Objects=Rectangle4 NumModes=1 Modes{Mode1{IntLine{middle of WG_sub.edge(5 of 12) -> middle of WG_sub.edge(7 of 12)} CharImp=Zpv}}
  2: Wave Port Objects=Rectangle3 NumModes=1 Modes{Mode1{IntLine{middle of Rectangle3.edge(z at corner) -> middle of Rectangle3.edge(z opposite corner)} CharImp=Zpi}}
setups:
  Setup1: HfssDriven MultipleAdaptiveFreqsSetup{Low=50GHz High=70GHz} MaxDeltaS=0.02 MaximumPasses=6 MinimumPasses=1 MinimumConvergedPasses=1 PercentRefinement=30 BasisOrder=1 PortAccuracy=2
    sweep Sweep: 50GHz to 70GHz step 0.1GHz; Type=Interpolating InterpTolerance=0.5 InterpMaxSolns=250 InterpUsePortImped=false PassivityErrorTolerance=0.0001
source amplitudes:
  1:1: 1W 0deg
  2:1: 0W 0deg
field plots:
  Mag_E1: E Field on Setup1 : LastAdaptive at Freq=60GHz Phase=0deg
reports:
  S Parameter Plot 1: dB(S(1,1)), dB(S(2,1)) vs Freq on Setup1 : Sweep; markers MX1 at x=6e+10, MY1 at y=-0.6, MY2 at y=-12.5
  Port Zo Plot 1: re(Zo(1:1)) vs Freq on Setup1 : Sweep; markers MX1 at x=6e+10
  S Parameter Plot 2: dB(S(2,1)) vs Freq on Setup1 : Sweep
