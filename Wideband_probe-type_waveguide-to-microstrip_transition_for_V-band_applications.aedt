# Ansys Electronics Desktop project, version 2021.2
materials:
  vacuum: permittivity=1
  Rogers RO4350 (tm): permittivity=3.66 dielectric_loss_tangent=0.004
  copper: permeability=0.999991 conductivity=58000000
  pec: conductivity=1e+30
  air: permittivity=1.0006 permeability=1.0000004
  Rogers RO3003 (tm): permittivity=3 dielectric_loss_tangent=0.0013

design best (HFSS, DrivenModal, model units mm)
variables:
  m_length = 6.4mm
  m_width = 4.8mm
  H1_thickness = 0.101mm
  H2_thickness = 0.438mm
  Line_thickness = 18um
  MSL_Length = 0.7mm
  MSL_width = 0.2mm
  Lg = 0.27mm
  SL_length = 1.4mm
  SL_width = 0.15mm
  probe_hole_width = 0.38mm
  WR15_width = 3.76mm
  WR15_Length = 1.88mm
  probe_length = 0.95mm
  probe_width = 0.38mm
  through_hole_radius = (1.55/2) mm
  shorted_high = 1.25mm  # 原文1.27 改成1.25試試看
  waveguide_thickness = 0.05mm
  Hst = 0.3mm
  Via_radius = 0.1mm
  Via_distance = 0.33mm
  WR_high = 4mm
geometry:
  H1 [Rogers RO4350 (tm)] = box(corner=(0mm, 0mm, H2_thickness+Line_thickness*2), size=(m_length, m_width, H1_thickness))
  H2 [Rogers RO4350 (tm)] = box(corner=(0mm, 0mm, Line_thickness), size=(m_length, m_width, H2_thickness))
  MSL_ground [copper] = box(corner=(0mm, 0mm, H2_thickness+Line_thickness*1), size=(m_length, m_width, Line_thickness))
  Lower_gound [copper] = box(corner=(0mm, 0mm, 0), size=(m_length, m_width, Line_thickness))
  upper_ground [copper] = box(corner=(0mm, 0mm, H1_thickness+H2_thickness+2*Line_thickness), size=(m_length-MSL_Length-Lg, m_width, Line_thickness))
  MSL [copper] = box(corner=(m_length-MSL_Length, m_width / 2 - MSL_width / 2, H1_thickness+H2_thickness+2*Line_thickness), size=(MSL_Length, MSL_width, Line_thickness))
  SL [copper] = box(corner=(m_length-MSL_Length - Lg - SL_length, m_width / 2 - SL_width / 2, H1_thickness+H2_thickness+2*Line_thickness), size=(SL_length, SL_width, Line_thickness))
  MSL_to_SL [copper] = rectangle(corner=(m_length - MSL_Length - Lg, m_width / 2 - SL_width / 2, H1_thickness + H2_thickness + 2 * Line_thickness), y_size=SL_width, z_size=Line_thickness)
  Rectangle2 = rectangle(corner=(m_length - MSL_Length, m_width / 2 - MSL_width / 2, H1_thickness + H2_thickness + 2 * Line_thickness), y_size=MSL_width, z_size=Line_thickness)
  MSL_to_SL.connect(Rectangle2)
  probe [copper] = box(corner=(m_length - MSL_Length - 2 * Lg - SL_length - probe_length, m_width / 2 -  probe_width / 2, H1_thickness + H2_thickness + 2 * Line_thickness), size=(probe_length, probe_width, Line_thickness))
  Rectangle3 = rectangle(corner=(m_length - MSL_Length - SL_length - 2 * Lg, m_width / 2 -probe_width / 2, H1_thickness + H2_thickness +2* Line_thickness), y_size=probe_width, z_size=Line_thickness)
  SL_to_probe [copper] = rectangle(corner=(m_length - MSL_Length - SL_length -  Lg, m_width / 2 -SL_width / 2, H1_thickness + H2_thickness +2* Line_thickness), y_size=SL_width, z_size=Line_thickness)
  SL_to_probe.connect(Rectangle3)
  through_hole_1 = cylinder(axis=Z, base_centre=(m_length - MSL_Length - SL_length- 2 * Lg - probe_length +0.15mm, m_width /2 - probe_width / 2 - through_hole_radius /2 - 0.5175 mm, Line_thickness), radius=through_hole_radius, height=H1_thickness +H2_thickness + 1* Line_thickness)
  shorted_WG [copper] = box(corner=(m_length - MSL_Length - SL_length -  Lg - WR15_Length -  waveguide_thickness, m_width / 2 - WR15_width / 2 - waveguide_thickness, H1_thickness + H2_thickness + 3 * Line_thickness), size=(WR15_Length + 2 * waveguide_thickness, WR15_width +2 * waveguide_thickness, shorted_high+waveguide_thickness))
  above_SL_ground [copper] = box(corner=(m_length - MSL_Length - SL_length - Lg + waveguide_thickness, m_width / 2 - probe_width / 2 - waveguide_thickness - Via_distance, H1_thickness + H2_thickness + 3 * Line_thickness), size=(SL_length - waveguide_thickness, probe_hole_width + 2 * waveguide_thickness+2*Via_distance, Hst + waveguide_thickness +Line_thickness))
  above_SL_vacuum [vacuum] = box(corner=(m_length - MSL_Length - SL_length - Lg, m_width / 2 - probe_width / 2 - Via_distance, H1_thickness + H2_thickness + 3 * Line_thickness), size=(SL_length, probe_hole_width +2 * Via_distance, Hst + Line_thickness))
  shorted_WG_sub [vacuum] = box(corner=(m_length - MSL_Length - SL_length -  Lg - WR15_Length, m_width / 2 - WR15_width / 2, H1_thickness + H2_thickness +2 * Line_thickness), size=(WR15_Length, WR15_width, shorted_high+Line_thickness))
  WG_sub [vacuum] = box(corner=(m_length - MSL_Length - SL_length -  Lg - WR15_Length, m_width / 2 - WR15_width / 2, - WR_high -waveguide_thickness+Line_thickness), size=(WR15_Length, WR15_width, WR_high + waveguide_thickness))
  Via [copper] = cylinder(axis=Z, base_centre=(m_length - MSL_Length - Lg - Via_distance / 2 - 0.05 mm, m_width / 2 - probe_hole_width / 2 - Via_distance / 2 -0.05mm, Line_thickness), radius=Via_radius, height=H1_thickness + H2_thickness + Line_thickness)
  Via_1, Via_2, Via_3 = Via.duplicate_along_line(step=(-0.33mm, 0mm, 0mm), total=4)
  Via_3_1..Via_3_5 = Via_3.duplicate_along_line(step=(0mm, -0.33mm, 0mm), total=7)  # copies kept: 1..5
  Via_bottom [copper], Via_3_5_1..Via_3_5_6 = Via_3_5.duplicate_along_line(step=(-0.33mm, 0mm, 0mm), total=8)
  Via.unite(Via_1, Via_2, Via_3, Via_3_1..Via_3_5, Via_3_5_1..Via_3_5_6)
  Via_4 = Via.duplicate_mirror(point=(4.3mm, 2.4mm, 0mm), normal=(0mm, 1mm, 0mm))
  Via_bottom.move(0.05mm, 0mm, 0mm)
  Via_3_5_7_1 = Via_bottom.duplicate_along_line(step=(0mm, 4.11mm, 0mm), total=2)
  Via_3_5_7_2..Via_3_5_7_15 = Via_bottom.duplicate_along_line(step=(0mm, 0.275mm, 0mm), total=15)
  Via_bottom.unite(Via_3_5_7_1..Via_3_5_7_15)
  Via.unite(Via_4)
  wave_port_1 [pec] = box(corner=(m_length, m_width / 2 - (5/2)*MSL_width, H2_thickness + Line_thickness), size=(0.1mm, 5 * MSL_width, 8*( H1_thickness )))
  wave_port_2 [pec] = box(corner=(m_length-MSL_Length-Lg-SL_length-WR15_Length-waveguide_thickness, m_width/2 - WR15_width/2 - waveguide_thickness, -WR_high-waveguide_thickness- 0.1 mm+Line_thickness), size=(WR15_Length+ 2 * waveguide_thickness, WR15_width + 2* waveguide_thickness, 0.1mm))
  Via_5 = Via.copy()
  Via_bottom_1 = Via_bottom.copy()
  H1.subtract(Via_5, Via_bottom_1)
  Via_6 = Via.copy()
  Via_bottom_2 = Via_bottom.copy()
  H2.subtract(Via_6, Via_bottom_2)
  Via_7 = Via.copy()
  Via_bottom_3 = Via_bottom.copy()
  MSL_ground.subtract(Via_7, Via_bottom_3)
  WG [copper] = box(corner=(m_length - MSL_Length - SL_length -  Lg - WR15_Length - waveguide_thickness, m_width / 2 - WR15_width / 2 - waveguide_thickness, - WR_high -waveguide_thickness+Line_thickness), size=(WR15_Length+2*waveguide_thickness, WR15_width+2*waveguide_thickness, WR_high + waveguide_thickness))
  Rectangle4 = rectangle(corner=(m_length - MSL_Length - SL_length -  Lg - WR15_Length, m_width / 2 - WR15_width / 2, - WR_high-waveguide_thickness+Line_thickness), x_size=WR15_Length, y_size=WR15_width)
  through_hole [vacuum] = through_hole_1.copy()
  through_hole_1.delete()
  WG_sub_1 = WG_sub.copy()
  Lower_gound.subtract(WG_sub_1)
  WG_sub_2 = WG_sub.copy()
  WG.subtract(WG_sub_2)
  above_SL_vacuum_1 = above_SL_vacuum.copy()
  shorted_WG.subtract(above_SL_vacuum_1)
  above_SL_vacuum_2 = above_SL_vacuum.copy()
  above_SL_ground.subtract(above_SL_vacuum_2)
  through_hole_1_10_1 = through_hole.duplicate_mirror(point=(2.315mm, 2.4mm, 0.593mm), normal=(-0.0048661224mm, -0.99998816mm, 0mm))
  through_hole.unite(through_hole_1_10_1)
  through_hole_2 = through_hole.copy()
  H1.subtract(through_hole_2)
  through_hole_3 = through_hole.copy()
  H2.subtract(through_hole_3)
  through_hole_4 = through_hole.copy()
  Lower_gound.subtract(through_hole_4)
  through_hole_5 = through_hole.copy()
  MSL_ground.subtract(through_hole_5)
  through_hole_6 = through_hole.copy()
  upper_ground.subtract(through_hole_6)
  Lower_gound_1 = Lower_gound.copy()
  WG.subtract(Lower_gound_1)
  shorted_WG_sub_1 = shorted_WG_sub.copy()
  shorted_WG.subtract(shorted_WG_sub_1)
  Region [vacuum] = region(percentage_offset=10 on all sides)
  above_SL_vaccum_2 = box(corner=(m_length - MSL_Length - Lg -SL_length, m_width/2 -probe_hole_width/2, H1_thickness+H2_thickness+2*Line_thickness), size=(SL_length, probe_hole_width, Line_thickness))
  above_SL_vacuum.unite(above_SL_vaccum_2)
  above_SL_vacuum_3 = above_SL_vacuum.copy()
  shorted_WG_sub_2 = shorted_WG_sub.copy()
  upper_ground.subtract(above_SL_vacuum_3, shorted_WG_sub_2)
  Rectangle5 = rectangle(corner=(m_length, m_width / 2 - (5/2)*MSL_width, H2_thickness + Line_thickness), y_size=5 * MSL_width, z_size=8*( H1_thickness ))
  H1_to_H2 [Rogers RO4350 (tm)] = box(corner=(m_length - MSL_Length - SL_length -  Lg - WR15_Length, m_width / 2 - WR15_width / 2, H2_thickness +1 * Line_thickness), size=(WR15_Length, WR15_width, Line_thickness))
  through_hole_7 = through_hole.copy()
  H1_to_H2.subtract(through_hole_7)
boundaries and excitations:
  Rad1: Radiation Objects=Region
  1: Wave Port Objects=Rectangle4 NumModes=1 Modes{Mode1{CharImp=Zpi}}
  2: Wave Port Objects=Rectangle5 NumModes=1 Modes{Mode1{CharImp=Zpi}}
setups:
  Setup1: HfssDriven MultipleAdaptiveFreqsSetup{Low=50GHz High=70GHz} MaxDeltaS=0.02 MaximumPasses=10 MinimumPasses=1 MinimumConvergedPasses=1 PercentRefinement=30 BasisOrder=1 PortAccuracy=2
    sweep Sweep: 50GHz to 75GHz step 0.05GHz; Type=Interpolating InterpTolerance=0.5 InterpMaxSolns=250 InterpUsePortImped=false PassivityErrorTolerance=0.0001
source amplitudes:
  1:1: 1W 0deg
  2:1: 0W 0deg
field plots:
  Mag_E1: E Field in above_SL_vacuum, through_hole, shorted_WG_sub, WG_sub on Setup1 : LastAdaptive at Freq=60GHz Phase=0deg
  Mag_E2, Mag_E3: E Field on Setup1 : LastAdaptive at Freq=60GHz Phase=0deg
reports:
  S Parameter Plot 2: dB(S(1,1)), dB(S(2,1)) vs Freq on Setup1 : Sweep; markers MX1 at x=6e+10, MY1 at y=-10, MY2 at y=-1, MY3 at y=-17

design best_test (HFSS, DrivenModal, model units mm)
variables:
  m_length = 6.4mm
  m_width = 4.8mm
  H1_thickness = 0.101mm
  H2_thickness = 0.438mm
  Line_thickness = 18um
  MSL_Length = 0.7mm
  MSL_width = 0.2mm
  Lg = 0.27mm
  SL_length = 1.4mm
  SL_width = 0.15mm
  probe_hole_width = 0.38mm
  WR15_width = 3.76mm
  WR15_Length = 1.88mm
  probe_length = 0.95mm
  probe_width = 0.38mm
  through_hole_radius = (1.55/2) mm
  shorted_high = 1.25mm  # 原文1.27 改成1.25試試看
  waveguide_thickness = 0.05mm
  Hst = 0.3mm
  Via_radius = 0.1mm
  Via_distance = 0.33mm
  WR_high = 4mm
geometry:
  H1 [Rogers RO4350 (tm)] = box(corner=(0mm, 0mm, H2_thickness+Line_thickness*2), size=(m_length, m_width, H1_thickness))
  H2 [Rogers RO4350 (tm)] = box(corner=(0mm, 0mm, Line_thickness), size=(m_length, m_width, H2_thickness))
  MSL_ground [copper] = box(corner=(0mm, 0mm, H2_thickness+Line_thickness*1), size=(m_length, m_width, Line_thickness))
  Lower_gound [copper] = box(corner=(0mm, 0mm, 0), size=(m_length, m_width, Line_thickness))
  upper_ground [copper] = box(corner=(0mm, 0mm, H1_thickness+H2_thickness+2*Line_thickness), size=(m_length-MSL_Length-Lg, m_width, Line_thickness))
  MSL [copper] = box(corner=(m_length-MSL_Length, m_width / 2 - MSL_width / 2, H1_thickness+H2_thickness+2*Line_thickness), size=(MSL_Length, MSL_width, Line_thickness))
  SL [copper] = box(corner=(m_length-MSL_Length - Lg - SL_length, m_width / 2 - SL_width / 2, H1_thickness+H2_thickness+2*Line_thickness), size=(SL_length, SL_width, Line_thickness))
  MSL_to_SL [copper] = rectangle(corner=(m_length - MSL_Length - Lg, m_width / 2 - SL_width / 2, H1_thickness + H2_thickness + 2 * Line_thickness), y_size=SL_width, z_size=Line_thickness)
  Rectangle2 = rectangle(corner=(m_length - MSL_Length, m_width / 2 - MSL_width / 2, H1_thickness + H2_thickness + 2 * Line_thickness), y_size=MSL_width, z_size=Line_thickness)
  MSL_to_SL.connect(Rectangle2)
  probe [copper] = box(corner=(m_length - MSL_Length - 2 * Lg - SL_length - probe_length, m_width / 2 -  probe_width / 2, H1_thickness + H2_thickness + 2 * Line_thickness), size=(probe_length, probe_width, Line_thickness))
  Rectangle3 = rectangle(corner=(m_length - MSL_Length - SL_length - 2 * Lg, m_width / 2 -probe_width / 2, H1_thickness + H2_thickness +2* Line_thickness), y_size=probe_width, z_size=Line_thickness)
  SL_to_probe [copper] = rectangle(corner=(m_length - MSL_Length - SL_length -  Lg, m_width / 2 -SL_width / 2, H1_thickness + H2_thickness +2* Line_thickness), y_size=SL_width, z_size=Line_thickness)
  SL_to_probe.connect(Rectangle3)
  through_hole_1 = cylinder(axis=Z, base_centre=(m_length - MSL_Length - SL_length- 2 * Lg - probe_length +0.15mm, m_width /2 - probe_width / 2 - through_hole_radius /2 - 0.5175 mm, Line_thickness), radius=through_hole_radius, height=H1_thickness +H2_thickness + 1* Line_thickness)
  shorted_WG [copper] = box(corner=(m_length - MSL_Length - SL_length -  Lg - WR15_Length -  waveguide_thickness, m_width / 2 - WR15_width / 2 - waveguide_thickness, H1_thickness + H2_thickness + 3 * Line_thickness), size=(WR15_Length + 2 * waveguide_thickness, WR15_width +2 * waveguide_thickness, shorted_high+waveguide_thickness))
  above_SL_ground [copper] = box(corner=(m_length - MSL_Length - SL_length - Lg + waveguide_thickness, m_width / 2 - probe_width / 2 - waveguide_thickness - Via_distance, H1_thickness + H2_thickness + 3 * Line_thickness), size=(SL_length - waveguide_thickness, probe_hole_width + 2 * waveguide_thickness+2*Via_distance, Hst + waveguide_thickness +Line_thickness))
  above_SL_vacuum = box(corner=(m_length - MSL_Length - SL_length - Lg, m_width / 2 - probe_width / 2 - Via_distance, H1_thickness + H2_thickness + 3 * Line_thickness), size=(SL_length, probe_hole_width +2 * Via_distance, Hst + Line_thickness))
  shorted_WG_sub = box(corner=(m_length - MSL_Length - SL_length -  Lg - WR15_Length, m_width / 2 - WR15_width / 2, H1_thickness + H2_thickness +2 * Line_thickness), size=(WR15_Length, WR15_width, shorted_high+Line_thickness))
  WG_sub = box(corner=(m_length - MSL_Length - SL_length -  Lg - WR15_Length, m_width / 2 - WR15_width / 2, - WR_high -waveguide_thickness+Line_thickness), size=(WR15_Length, WR15_width, WR_high + waveguide_thickness))
  Via [copper] = cylinder(axis=Z, base_centre=(m_length - MSL_Length - Lg - Via_distance / 2 - 0.05 mm, m_width / 2 - probe_hole_width / 2 - Via_distance / 2 -0.05mm, Line_thickness), radius=Via_radius, height=H1_thickness + H2_thickness + Line_thickness)
  Via_1, Via_2, Via_3 = Via.duplicate_along_line(step=(-0.33mm, 0mm, 0mm), total=4)
  Via_3_1..Via_3_5 = Via_3.duplicate_along_line(step=(0mm, -0.33mm, 0mm), total=7)  # copies kept: 1..5
  Via_bottom [copper], Via_3_5_1..Via_3_5_6 = Via_3_5.duplicate_along_line(step=(-0.33mm, 0mm, 0mm), total=8)
  Via.unite(Via_1, Via_2, Via_3, Via_3_1..Via_3_5, Via_3_5_1..Via_3_5_6)
  Via_4 = Via.duplicate_mirror(point=(4.3mm, 2.4mm, 0mm), normal=(0mm, 1mm, 0mm))
  Via_bottom.move(0.05mm, 0mm, 0mm)
  Via_3_5_7_1 = Via_bottom.duplicate_along_line(step=(0mm, 4.11mm, 0mm), total=2)
  Via_3_5_7_2..Via_3_5_7_15 = Via_bottom.duplicate_along_line(step=(0mm, 0.275mm, 0mm), total=15)
  Via_bottom.unite(Via_3_5_7_1..Via_3_5_7_15)
  Via.unite(Via_4)
  wave_port_1 [pec] = box(corner=(m_length, m_width / 2 - (5/2)*MSL_width, H2_thickness + Line_thickness), size=(0.1mm, 5 * MSL_width, 8*( H1_thickness )))
  wave_port_2 [pec] = box(corner=(m_length-MSL_Length-Lg-SL_length-WR15_Length-waveguide_thickness, m_width/2 - WR15_width/2 - waveguide_thickness, -WR_high-waveguide_thickness- 0.1 mm+Line_thickness), size=(WR15_Length+ 2 * waveguide_thickness, WR15_width + 2* waveguide_thickness, 0.1mm))
  Via_5 = Via.copy()
  Via_bottom_1 = Via_bottom.copy()
  H1.subtract(Via_5, Via_bottom_1)
  Via_6 = Via.copy()
  Via_bottom_2 = Via_bottom.copy()
  H2.subtract(Via_6, Via_bottom_2)
  Via_7 = Via.copy()
  Via_bottom_3 = Via_bottom.copy()
  MSL_ground.subtract(Via_7, Via_bottom_3)
  WG [copper] = box(corner=(m_length - MSL_Length - SL_length -  Lg - WR15_Length - waveguide_thickness, m_width / 2 - WR15_width / 2 - waveguide_thickness, - WR_high -waveguide_thickness+Line_thickness), size=(WR15_Length+2*waveguide_thickness, WR15_width+2*waveguide_thickness, WR_high + waveguide_thickness))
  Rectangle4 = rectangle(corner=(m_length - MSL_Length - SL_length -  Lg - WR15_Length, m_width / 2 - WR15_width / 2, - WR_high-waveguide_thickness+Line_thickness), x_size=WR15_Length, y_size=WR15_width)
  through_hole = through_hole_1.copy()
  through_hole_1.delete()
  WG_sub_1 = WG_sub.copy()
  Lower_gound.subtract(WG_sub_1)
  WG_sub_2 = WG_sub.copy()
  WG_sub.delete()
  WG.subtract(WG_sub_2)
  above_SL_vacuum_1 = above_SL_vacuum.copy()
  shorted_WG.subtract(above_SL_vacuum_1)
  above_SL_vacuum_2 = above_SL_vacuum.copy()
  above_SL_ground.subtract(above_SL_vacuum_2)
  through_hole_1_10_1 = through_hole.duplicate_mirror(point=(2.315mm, 2.4mm, 0.593mm), normal=(-0.0048661224mm, -0.99998816mm, 0mm))
  through_hole.unite(through_hole_1_10_1)
  through_hole_2 = through_hole.copy()
  H1.subtract(through_hole_2)
  through_hole_3 = through_hole.copy()
  H2.subtract(through_hole_3)
  through_hole_4 = through_hole.copy()
  Lower_gound.subtract(through_hole_4)
  through_hole_5 = through_hole.copy()
  MSL_ground.subtract(through_hole_5)
  through_hole_6 = through_hole.copy()
  upper_ground.subtract(through_hole_6)
  Lower_gound_1 = Lower_gound.copy()
  WG.subtract(Lower_gound_1)
  shorted_WG_sub_1 = shorted_WG_sub.copy()
  shorted_WG.subtract(shorted_WG_sub_1)
  Region [air] = region(percentage_offset=10 on all sides)
  above_SL_vaccum_2 = box(corner=(m_length - MSL_Length - Lg -SL_length, m_width/2 -probe_hole_width/2, H1_thickness+H2_thickness+2*Line_thickness), size=(SL_length, probe_hole_width, Line_thickness))
  above_SL_vacuum.unite(above_SL_vaccum_2)
  above_SL_vacuum_3 = above_SL_vacuum.copy()
  above_SL_vacuum.delete()
  shorted_WG_sub_2 = shorted_WG_sub.copy()
  shorted_WG_sub.delete()
  upper_ground.subtract(above_SL_vacuum_3, shorted_WG_sub_2)
  Rectangle5 = rectangle(corner=(m_length, m_width / 2 - (5/2)*MSL_width, H2_thickness + Line_thickness), y_size=5 * MSL_width, z_size=8*( H1_thickness ))
  H1_to_H2 [Rogers RO4350 (tm)] = box(corner=(m_length - MSL_Length - SL_length -  Lg - WR15_Length, m_width / 2 - WR15_width / 2, H2_thickness +1 * Line_thickness), size=(WR15_Length, WR15_width, Line_thickness))
  through_hole_7 = through_hole.copy()
  through_hole.delete()
  H1_to_H2.subtract(through_hole_7)
boundaries and excitations:
  Rad1: Radiation Objects=Region
  1: Wave Port Objects=Rectangle4 NumModes=1 Modes{Mode1{CharImp=Zpi}}
  2: Wave Port Objects=Rectangle5 NumModes=1 Modes{Mode1{CharImp=Zpi}}
setups:
  Setup1: HfssDriven MultipleAdaptiveFreqsSetup{Low=50GHz High=70GHz} MaxDeltaS=0.02 MaximumPasses=10 MinimumPasses=1 MinimumConvergedPasses=1 PercentRefinement=30 BasisOrder=1 PortAccuracy=2
    sweep Sweep: 50GHz to 70GHz step 0.5GHz; Type=Interpolating InterpTolerance=0.5 InterpMaxSolns=250 InterpUsePortImped=false PassivityErrorTolerance=0.0001
source amplitudes:
  1:1: 1W 0deg
  2:1: 0W 0deg
field plots:
  Mag_E2: E Field over SL.face(all 6) upper_ground.face(all 14) Rectangle2.face MSL_to_SL.face(at (5.43, 2.4, 0.584), at (5.565, 2.4, 0.575), at (5.565, 2.4875, 0.584), at (5.565, 2.4, 0.593), at (5.565, 2.3125, 0.584)) probe.face(all 6) MSL.face(all 6) on Setup1 : LastAdaptive at Freq=60GHz Phase=0deg
  Mag_E3: E Field on Setup1 : LastAdaptive at Freq=60GHz Phase=0deg
reports:
  S Parameter Plot 2: dB(S(1,1)), dB(S(2,1)) vs Freq on Setup1 : Sweep; markers MX1 at x=6e+10, MY1 at y=-10, MY2 at y=-0.7, MY3 at y=-17
  S Parameter Plot 3: dB(S(2,1)) vs Freq on Setup1 : Sweep

design best1 (HFSS, DrivenModal, model units mm)
variables:
  m_length = 6.4mm
  m_width = 4.8mm
  H1_thickness = 0.101mm
  H2_thickness = 0.438mm
  Line_thickness = 18um
  MSL_Length = 0.7mm
  MSL_width = 0.2mm
  Lg = 0.27mm
  SL_length = 1.4mm
  SL_width = 0.15mm
  probe_hole_width = 0.38mm
  WR15_width = 3.76mm
  WR15_Length = 1.88mm
  probe_length = 0.95mm
  probe_width = 0.38mm
  through_hole_radius = (1.55/2) mm
  shorted_high = 1.25mm  # 原文1.27 改成1.25試試看
  waveguide_thickness = 0.05mm
  Hst = 0.3mm
  Via_radius = 0.1mm
  Via_distance = 0.33mm
  WR_high = 4mm
  hole_distance = 0.5175mm
geometry:
  H1 [Rogers RO4350 (tm)] = box(corner=(0mm, 0mm, H2_thickness+Line_thickness*2), size=(m_length, m_width, H1_thickness))
  H2 [Rogers RO4350 (tm)] = box(corner=(0mm, 0mm, Line_thickness), size=(m_length, m_width, H2_thickness))
  MSL_ground [copper] = box(corner=(0mm, 0mm, H2_thickness+Line_thickness*1), size=(m_length, m_width, Line_thickness))
  Lower_gound [copper] = box(corner=(0mm, 0mm, 0), size=(m_length, m_width, Line_thickness))
  upper_ground [copper] = box(corner=(0mm, 0mm, H1_thickness+H2_thickness+2*Line_thickness), size=(m_length-MSL_Length-Lg, m_width, Line_thickness))
  MSL [copper] = box(corner=(m_length-MSL_Length, m_width / 2 - MSL_width / 2, H1_thickness+H2_thickness+2*Line_thickness), size=(MSL_Length, MSL_width, Line_thickness))
  SL [copper] = box(corner=(m_length-MSL_Length - Lg - SL_length, m_width / 2 - SL_width / 2, H1_thickness+H2_thickness+2*Line_thickness), size=(SL_length, SL_width, Line_thickness))
  MSL_to_SL [copper] = rectangle(corner=(m_length - MSL_Length - Lg, m_width / 2 - SL_width / 2, H1_thickness + H2_thickness + 2 * Line_thickness), y_size=SL_width, z_size=Line_thickness)
  Rectangle2 = rectangle(corner=(m_length - MSL_Length, m_width / 2 - MSL_width / 2, H1_thickness + H2_thickness + 2 * Line_thickness), y_size=MSL_width, z_size=Line_thickness)
  MSL_to_SL.connect(Rectangle2)
  probe [copper] = box(corner=(m_length - MSL_Length - 2 * Lg - SL_length - probe_length, m_width / 2 -  probe_width / 2, H1_thickness + H2_thickness + 2 * Line_thickness), size=(probe_length, probe_width, Line_thickness))
  Rectangle3 = rectangle(corner=(m_length - MSL_Length - SL_length - 2 * Lg, m_width / 2 -probe_width / 2, H1_thickness + H2_thickness +2* Line_thickness), y_size=probe_width, z_size=Line_thickness)
  SL_to_probe [copper] = rectangle(corner=(m_length - MSL_Length - SL_length -  Lg, m_width / 2 -SL_width / 2, H1_thickness + H2_thickness +2* Line_thickness), y_size=SL_width, z_size=Line_thickness)
  SL_to_probe.connect(Rectangle3)
  through_hole_1 = cylinder(axis=Z, base_centre=(m_length - MSL_Length - SL_length- 2 * Lg - probe_length +0.15mm, m_width /2 - probe_width / 2 - through_hole_radius /2  - hole_distance, Line_thickness), radius=through_hole_radius, height=H1_thickness +H2_thickness + 1* Line_thickness)
  shorted_WG [copper] = box(corner=(m_length - MSL_Length - SL_length -  Lg - WR15_Length -  waveguide_thickness, m_width / 2 - WR15_width / 2 - waveguide_thickness, H1_thickness + H2_thickness + 3 * Line_thickness), size=(WR15_Length + 2 * waveguide_thickness, WR15_width +2 * waveguide_thickness, shorted_high+waveguide_thickness))
  above_SL_ground [copper] = box(corner=(m_length - MSL_Length - SL_length - Lg + waveguide_thickness, m_width / 2 - probe_width / 2 - waveguide_thickness - Via_distance, H1_thickness + H2_thickness + 3 * Line_thickness), size=(SL_length - waveguide_thickness, probe_hole_width + 2 * waveguide_thickness+2*Via_distance, Hst + waveguide_thickness +Line_thickness))
  above_SL_vacuum = box(corner=(m_length - MSL_Length - SL_length - Lg, m_width / 2 - probe_width / 2 - Via_distance, H1_thickness + H2_thickness + 3 * Line_thickness), size=(SL_length, probe_hole_width +2 * Via_distance, Hst + Line_thickness))
  shorted_WG_sub = box(corner=(m_length - MSL_Length - SL_length -  Lg - WR15_Length, m_width / 2 - WR15_width / 2, H1_thickness + H2_thickness +2 * Line_thickness), size=(WR15_Length, WR15_width, shorted_high+Line_thickness))
  WG_sub = box(corner=(m_length - MSL_Length - SL_length -  Lg - WR15_Length, m_width / 2 - WR15_width / 2, - WR_high -waveguide_thickness+Line_thickness), size=(WR15_Length, WR15_width, WR_high + waveguide_thickness))
  Via [copper] = cylinder(axis=Z, base_centre=(m_length - MSL_Length - Lg - Via_distance / 2 - 0.05 mm, m_width / 2 - probe_hole_width / 2 - Via_distance / 2 -0.05mm, Line_thickness), radius=Via_radius, height=H1_thickness + H2_thickness + Line_thickness)
  Via_1, Via_2, Via_3 = Via.duplicate_along_line(step=(-0.33mm, 0mm, 0mm), total=4)
  Via_3_1..Via_3_5 = Via_3.duplicate_along_line(step=(0mm, -0.33mm, 0mm), total=7)  # copies kept: 1..5
  Via_bottom [copper], Via_3_5_1..Via_3_5_6 = Via_3_5.duplicate_along_line(step=(-0.33mm, 0mm, 0mm), total=8)
  Via.unite(Via_1, Via_2, Via_3, Via_3_1..Via_3_5, Via_3_5_1..Via_3_5_6)
  Via_4 = Via.duplicate_mirror(point=(4.3mm, 2.4mm, 0mm), normal=(0mm, 1mm, 0mm))
  Via_bottom.move(0.05mm, 0mm, 0mm)
  Via_3_5_7_1 = Via_bottom.duplicate_along_line(step=(0mm, 4.11mm, 0mm), total=2)
  Via_3_5_7_2..Via_3_5_7_15 = Via_bottom.duplicate_along_line(step=(0mm, 0.275mm, 0mm), total=15)
  Via_bottom.unite(Via_3_5_7_1..Via_3_5_7_15)
  Via.unite(Via_4)
  wave_port_1 [pec] = box(corner=(m_length, m_width / 2 - (5/2)*MSL_width, H2_thickness + Line_thickness), size=(0.1mm, 5 * MSL_width, 8*( H1_thickness )))
  wave_port_2 [pec] = box(corner=(m_length-MSL_Length-Lg-SL_length-WR15_Length-waveguide_thickness, m_width/2 - WR15_width/2 - waveguide_thickness, -WR_high-waveguide_thickness- 0.1 mm+Line_thickness), size=(WR15_Length+ 2 * waveguide_thickness, WR15_width + 2* waveguide_thickness, 0.1mm))
  Via_5 = Via.copy()
  Via_bottom_1 = Via_bottom.copy()
  H1.subtract(Via_5, Via_bottom_1)
  Via_6 = Via.copy()
  Via_bottom_2 = Via_bottom.copy()
  H2.subtract(Via_6, Via_bottom_2)
  Via_7 = Via.copy()
  Via_bottom_3 = Via_bottom.copy()
  MSL_ground.subtract(Via_7, Via_bottom_3)
  WG [copper] = box(corner=(m_length - MSL_Length - SL_length -  Lg - WR15_Length - waveguide_thickness, m_width / 2 - WR15_width / 2 - waveguide_thickness, - WR_high -waveguide_thickness+Line_thickness), size=(WR15_Length+2*waveguide_thickness, WR15_width+2*waveguide_thickness, WR_high + waveguide_thickness))
  Rectangle4 = rectangle(corner=(m_length - MSL_Length - SL_length -  Lg - WR15_Length, m_width / 2 - WR15_width / 2, - WR_high-waveguide_thickness+Line_thickness), x_size=WR15_Length, y_size=WR15_width)
  through_hole = through_hole_1.copy()
  through_hole_1.delete()
  WG_sub_1 = WG_sub.copy()
  Lower_gound.subtract(WG_sub_1)
  WG_sub_2 = WG_sub.copy()
  WG_sub.delete()
  WG.subtract(WG_sub_2)
  above_SL_vacuum_1 = above_SL_vacuum.copy()
  shorted_WG.subtract(above_SL_vacuum_1)
  above_SL_vacuum_2 = above_SL_vacuum.copy()
  above_SL_ground.subtract(above_SL_vacuum_2)
  through_hole_1_10_1 = through_hole.duplicate_mirror(point=(2.315mm, 2.4mm, 0.593mm), normal=(-0.0048661224mm, -0.99998816mm, 0mm))
  through_hole.unite(through_hole_1_10_1)
  through_hole_2 = through_hole.copy()
  H1.subtract(through_hole_2)
  through_hole_3 = through_hole.copy()
  H2.subtract(through_hole_3)
  through_hole_4 = through_hole.copy()
  Lower_gound.subtract(through_hole_4)
  through_hole_5 = through_hole.copy()
  MSL_ground.subtract(through_hole_5)
  through_hole_6 = through_hole.copy()
  upper_ground.subtract(through_hole_6)
  Lower_gound_1 = Lower_gound.copy()
  WG.subtract(Lower_gound_1)
  shorted_WG_sub_1 = shorted_WG_sub.copy()
  shorted_WG.subtract(shorted_WG_sub_1)
  Region [air] = region(percentage_offset=10 on all sides)
  above_SL_vaccum_2 = box(corner=(m_length - MSL_Length - Lg -SL_length, m_width/2 -probe_hole_width/2, H1_thickness+H2_thickness+2*Line_thickness), size=(SL_length, probe_hole_width, Line_thickness))
  above_SL_vacuum.unite(above_SL_vaccum_2)
  above_SL_vacuum_3 = above_SL_vacuum.copy()
  above_SL_vacuum.delete()
  shorted_WG_sub_2 = shorted_WG_sub.copy()
  shorted_WG_sub.delete()
  upper_ground.subtract(above_SL_vacuum_3, shorted_WG_sub_2)
  Rectangle5 = rectangle(corner=(m_length, m_width / 2 - (5/2)*MSL_width, H2_thickness + Line_thickness), y_size=5 * MSL_width, z_size=8*( H1_thickness ))
  H1_to_H2 [Rogers RO4350 (tm)] = box(corner=(m_length - MSL_Length - SL_length -  Lg - WR15_Length, m_width / 2 - WR15_width / 2, H2_thickness +1 * Line_thickness), size=(WR15_Length, WR15_width, Line_thickness))
  through_hole_7 = through_hole.copy()
  through_hole.delete()
  H1_to_H2.subtract(through_hole_7)
boundaries and excitations:
  Rad1: Radiation Objects=Region
  1: Wave Port Objects=Rectangle4 NumModes=1 Modes{Mode1{CharImp=Zpi}}
  2: Wave Port Objects=Rectangle5 NumModes=1 Modes{Mode1{CharImp=Zpi}}
setups:
  Setup1: HfssDriven MultipleAdaptiveFreqsSetup{Low=50GHz High=70GHz} MaxDeltaS=0.02 MaximumPasses=10 MinimumPasses=1 MinimumConvergedPasses=1 PercentRefinement=30 BasisOrder=1 PortAccuracy=2
    sweep Sweep: 50GHz to 70GHz step 0.05GHz; Type=Interpolating InterpTolerance=0.5 InterpMaxSolns=250 InterpUsePortImped=false PassivityErrorTolerance=0.0001
source amplitudes:
  1:1: 1W 0deg
  2:1: 0W 0deg
optimetrics:
  ParametricSetup1: Parametric Sim._Setups=[Setup1]
    sweep hole_distance: LIN 0.4675mm 0.5675mm 0.05mm
field plots:
  Mag_E2: E Field over SL.face(all 6) upper_ground.face(all 14) Rectangle2.face MSL_to_SL.face(at (5.43, 2.4, 0.584), at (5.565, 2.4, 0.575), at (5.565, 2.4875, 0.584), at (5.565, 2.4, 0.593), at (5.565, 2.3125, 0.584)) probe.face(all 6) MSL.face(all 6) on Setup1 : LastAdaptive at Freq=60GHz Phase=0deg
  Mag_E3: E Field on Setup1 : LastAdaptive at Freq=60GHz Phase=0deg
reports:
  S Parameter Plot 2: dB(S(1,1)), dB(S(2,1)) vs Freq on Setup1 : Sweep; markers MX1 at x=6e+10, MY1 at y=-10, MY2 at y=-1, MY3 at y=-17
